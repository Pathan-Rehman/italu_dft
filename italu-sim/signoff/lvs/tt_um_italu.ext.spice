* NGSPICE file created from tt_um_italu.ext - technology: ihp-sg13g2

.subckt sg13g2_nor2_1 A VDD Y VSS B
X0 Y A VSS VSS sg13_lv_nmos ad=0.1406p pd=1.12u as=0.2516p ps=2.16u w=0.74u l=0.13u
X1 a_170_412# A VDD VDD sg13_lv_pmos ad=0.1176p pd=1.33u as=0.4032p ps=2.96u w=1.12u l=0.13u
X2 VSS B Y VSS sg13_lv_nmos ad=0.2516p pd=2.16u as=0.1406p ps=1.12u w=0.74u l=0.13u
X3 Y B a_170_412# VDD sg13_lv_pmos ad=0.3808p pd=2.92u as=0.1176p ps=1.33u w=1.12u l=0.13u
.ends

.subckt sg13g2_a21oi_1 VDD VSS A2 A1 B1 Y
X0 Y B1 VSS VSS sg13_lv_nmos ad=0.1406p pd=1.12u as=0.2516p ps=2.16u w=0.74u l=0.13u
X1 a_257_140# A1 Y VSS sg13_lv_nmos ad=0.1406p pd=1.12u as=0.1406p ps=1.12u w=0.74u l=0.13u
X2 VSS A2 a_257_140# VSS sg13_lv_nmos ad=0.2516p pd=2.16u as=0.1406p ps=1.12u w=0.74u l=0.13u
X3 a_155_412# B1 Y VDD sg13_lv_pmos ad=0.2128p pd=1.5u as=0.3808p ps=2.92u w=1.12u l=0.13u
X4 VDD A1 a_155_412# VDD sg13_lv_pmos ad=0.2128p pd=1.5u as=0.2128p ps=1.5u w=1.12u l=0.13u
X5 a_155_412# A2 VDD VDD sg13_lv_pmos ad=0.3808p pd=2.92u as=0.2128p ps=1.5u w=1.12u l=0.13u
.ends

.subckt sg13g2_xnor2_1 Y B VDD A VSS
X0 a_192_429# A VDD VDD sg13_lv_pmos ad=0.1596p pd=1.22u as=0.4536p ps=2.76u w=0.84u l=0.13u
X1 VDD B a_192_429# VDD sg13_lv_pmos ad=0.2891p pd=1.695u as=0.1596p ps=1.22u w=0.84u l=0.13u
X2 VSS A a_341_118# VSS sg13_lv_nmos ad=0.1898p pd=1.36u as=0.2516p ps=2.16u w=0.74u l=0.13u
X3 a_435_412# A VDD VDD sg13_lv_pmos ad=0.1428p pd=1.375u as=0.2891p ps=1.695u w=1.12u l=0.13u
X4 a_155_160# A VSS VSS sg13_lv_nmos ad=78.39999f pd=0.885u as=0.2272p ps=1.99u w=0.64u l=0.13u
X5 a_341_118# B VSS VSS sg13_lv_nmos ad=0.1406p pd=1.12u as=0.1898p ps=1.36u w=0.74u l=0.13u
X6 Y a_192_429# a_341_118# VSS sg13_lv_nmos ad=0.2516p pd=2.16u as=0.1406p ps=1.12u w=0.74u l=0.13u
X7 VDD a_192_429# Y VDD sg13_lv_pmos ad=0.3808p pd=2.92u as=0.2408p ps=1.55u w=1.12u l=0.13u
X8 a_192_429# B a_155_160# VSS sg13_lv_nmos ad=0.2176p pd=1.96u as=78.39999f ps=0.885u w=0.64u l=0.13u
X9 Y B a_435_412# VDD sg13_lv_pmos ad=0.2408p pd=1.55u as=0.1428p ps=1.375u w=1.12u l=0.13u
.ends

.subckt sg13g2_dfrbpq_1 VDD D Q CLK VSS RESET_B
X0 VDD RESET_B a_298_337# VDD sg13_lv_pmos ad=0.1563p pd=1.22u as=0.147p ps=1.54u w=0.42u l=0.13u
X1 VSS RESET_B a_132_114# VSS sg13_lv_nmos ad=0.1626p pd=1.415u as=60.89999f ps=0.71u w=0.42u l=0.13u
X2 a_550_127# RESET_B VSS VSS sg13_lv_nmos ad=37.8f pd=0.6u as=0.1701p ps=1.65u w=0.42u l=0.13u
X3 a_298_337# a_741_93# a_681_505# VDD sg13_lv_pmos ad=79.8f pd=0.8u as=63f ps=0.72u w=0.42u l=0.13u
X4 a_1840_334# a_1583_191# a_2002_114# VSS sg13_lv_nmos ad=0.1428p pd=1.52u as=37.8f ps=0.6u w=0.42u l=0.13u
X5 a_38_114# a_843_236# a_298_337# VDD sg13_lv_pmos ad=0.1428p pd=1.52u as=79.8f ps=0.8u w=0.42u l=0.13u
X6 a_741_93# CLK VSS VSS sg13_lv_nmos ad=0.2516p pd=2.16u as=2.26778p ps=14.665u w=0.74u l=0.13u
X7 a_38_114# D VDD VDD sg13_lv_pmos ad=79.8f pd=0.8u as=0.1428p ps=1.52u w=0.42u l=0.13u
X8 a_741_93# CLK VDD VDD sg13_lv_pmos ad=0.4088p pd=2.97u as=1.12285p ps=7.26u w=1.12u l=0.13u
X9 VSS a_741_93# a_843_236# VSS sg13_lv_nmos ad=2.26778p pd=14.665u as=0.2516p ps=2.16u w=0.74u l=0.13u
X10 VSS a_1840_334# a_1489_191# VSS sg13_lv_nmos ad=79.8f pd=0.8u as=0.1428p ps=1.52u w=0.42u l=0.13u
X11 VDD RESET_B a_38_114# VDD sg13_lv_pmos ad=0.36237p pd=2.605u as=79.8f ps=0.8u w=0.42u l=0.13u
X12 a_324_432# a_298_337# VSS VSS sg13_lv_nmos ad=0.2516p pd=2.16u as=0.1626p ps=1.415u w=0.74u l=0.13u
X13 VDD a_741_93# a_843_236# VDD sg13_lv_pmos ad=1.12285p pd=7.26u as=0.3864p ps=2.93u w=1.12u l=0.13u
X14 a_2002_114# RESET_B VSS VSS sg13_lv_nmos ad=37.8f pd=0.6u as=79.8f ps=0.8u w=0.42u l=0.13u
X15 VDD a_1583_191# a_2250_412# VDD sg13_lv_pmos ad=0.2128p pd=1.5u as=0.3864p ps=2.93u w=1.12u l=0.13u
X16 Q a_2250_412# VDD VDD sg13_lv_pmos ad=0.3808p pd=2.92u as=0.2128p ps=1.5u w=1.12u l=0.13u
X17 a_132_114# D a_38_114# VSS sg13_lv_nmos ad=60.89999f pd=0.71u as=0.1428p ps=1.52u w=0.42u l=0.13u
X18 a_1785_429# a_843_236# a_1583_191# VDD sg13_lv_pmos ad=93.45f pd=0.865u as=0.2048p ps=1.63u w=0.42u l=0.13u
X19 VDD a_1583_191# a_1840_334# VDD sg13_lv_pmos ad=1.12285p pd=7.26u as=79.8f ps=0.8u w=0.42u l=0.13u
X20 a_1583_191# a_741_93# a_324_432# VDD sg13_lv_pmos ad=0.2048p pd=1.63u as=0.34p ps=2.68u w=1u l=0.13u
X21 a_1583_191# a_741_93# a_1489_191# VSS sg13_lv_nmos ad=0.12665p pd=1.145u as=0.1428p ps=1.52u w=0.42u l=0.13u
X22 VDD a_1840_334# a_1785_429# VDD sg13_lv_pmos ad=1.12285p pd=7.26u as=93.45f ps=0.865u w=0.42u l=0.13u
X23 a_1840_334# RESET_B VDD VDD sg13_lv_pmos ad=79.8f pd=0.8u as=1.12285p ps=7.26u w=0.42u l=0.13u
X24 a_324_432# a_843_236# a_1583_191# VSS sg13_lv_nmos ad=0.3473p pd=2.71u as=0.12665p ps=1.145u w=0.74u l=0.13u
X25 a_298_337# a_741_93# a_38_114# VSS sg13_lv_nmos ad=79.8f pd=0.8u as=0.1296p ps=1.52u w=0.42u l=0.13u
X26 a_612_127# a_324_432# a_550_127# VSS sg13_lv_nmos ad=0.1428p pd=1.52u as=37.8f ps=0.6u w=0.42u l=0.13u
X27 a_681_505# a_324_432# VDD VDD sg13_lv_pmos ad=63f pd=0.72u as=0.1563p ps=1.22u w=0.42u l=0.13u
X28 a_612_127# a_843_236# a_298_337# VSS sg13_lv_nmos ad=0.2373p pd=1.97u as=79.8f ps=0.8u w=0.42u l=0.13u
X29 VSS a_1583_191# a_2250_412# VSS sg13_lv_nmos ad=0.1406p pd=1.12u as=0.2516p ps=2.16u w=0.74u l=0.13u
X30 a_324_432# a_298_337# VDD VDD sg13_lv_pmos ad=0.34p pd=2.68u as=0.36237p ps=2.605u w=1u l=0.13u
X31 Q a_2250_412# VSS VSS sg13_lv_nmos ad=0.2516p pd=2.16u as=0.1406p ps=1.12u w=0.74u l=0.13u
.ends

.subckt sg13g2_or2_1 A VSS B X VDD
X0 a_142_492# B a_48_492# VDD sg13_lv_pmos ad=0.1596p pd=1.22u as=0.2856p ps=2.36u w=0.84u l=0.13u
X1 VDD A a_142_492# VDD sg13_lv_pmos ad=0.2226p pd=1.535u as=0.1596p ps=1.22u w=0.84u l=0.13u
X2 X a_48_492# VSS VSS sg13_lv_nmos ad=0.2516p pd=2.16u as=0.1469p ps=1.155u w=0.74u l=0.13u
X3 VSS A a_48_492# VSS sg13_lv_nmos ad=0.1469p pd=1.155u as=0.1045p ps=0.93u w=0.55u l=0.13u
X4 a_48_492# B VSS VSS sg13_lv_nmos ad=0.1045p pd=0.93u as=0.187p ps=1.78u w=0.55u l=0.13u
X5 X a_48_492# VDD VDD sg13_lv_pmos ad=0.3976p pd=2.95u as=0.2226p ps=1.535u w=1.12u l=0.13u
.ends

.subckt sg13g2_o21ai_1 VSS VDD Y B1 A2 A1
X0 VSS A1 a_22_110# VSS sg13_lv_nmos ad=0.1406p pd=1.12u as=0.2516p ps=2.16u w=0.74u l=0.15u
X1 a_120_432# A1 VDD VDD sg13_lv_pmos ad=0.2128p pd=1.5u as=0.3808p ps=2.92u w=1.12u l=0.15u
X2 a_22_110# A2 VSS VSS sg13_lv_nmos ad=0.1406p pd=1.12u as=0.1406p ps=1.12u w=0.74u l=0.15u
X3 Y B1 a_22_110# VSS sg13_lv_nmos ad=0.2516p pd=2.16u as=0.1406p ps=1.12u w=0.74u l=0.15u
X4 Y A2 a_120_432# VDD sg13_lv_pmos ad=0.2128p pd=1.5u as=0.2128p ps=1.5u w=1.12u l=0.15u
X5 VDD B1 Y VDD sg13_lv_pmos ad=0.3808p pd=2.92u as=0.2128p ps=1.5u w=1.12u l=0.15u
.ends

.subckt sg13g2_buf_4 X VSS A VDD
X0 X a_111_82# VSS VSS sg13_lv_nmos ad=0.1406p pd=1.12u as=0.2516p ps=2.16u w=0.74u l=0.13u
X1 X a_111_82# VDD VDD sg13_lv_pmos ad=0.2128p pd=1.5u as=0.3808p ps=2.92u w=1.12u l=0.13u
X2 VSS a_111_82# X VSS sg13_lv_nmos ad=0.1406p pd=1.12u as=0.1406p ps=1.12u w=0.74u l=0.13u
X3 X a_111_82# VSS VSS sg13_lv_nmos ad=0.1406p pd=1.12u as=0.1406p ps=1.12u w=0.74u l=0.13u
X4 VDD a_111_82# X VDD sg13_lv_pmos ad=0.2128p pd=1.5u as=0.2128p ps=1.5u w=1.12u l=0.13u
X5 X a_111_82# VDD VDD sg13_lv_pmos ad=0.2128p pd=1.5u as=0.2128p ps=1.5u w=1.12u l=0.13u
X6 VSS a_111_82# X VSS sg13_lv_nmos ad=0.3293p pd=1.63u as=0.1406p ps=1.12u w=0.74u l=0.13u
X7 VDD a_111_82# X VDD sg13_lv_pmos ad=0.203p pd=1.5u as=0.2128p ps=1.5u w=1.12u l=0.13u
X8 a_111_82# A VSS VSS sg13_lv_nmos ad=0.2516p pd=2.16u as=0.3293p ps=1.63u w=0.74u l=0.13u
X9 a_111_82# A VDD VDD sg13_lv_pmos ad=0.1596p pd=1.22u as=0.203p ps=1.5u w=0.84u l=0.13u
X10 VDD A a_111_82# VDD sg13_lv_pmos ad=0.2856p pd=2.36u as=0.1596p ps=1.22u w=0.84u l=0.13u
.ends

.subckt sg13g2_nand2_1 Y VDD A VSS B
X0 a_154_118# B VSS VSS sg13_lv_nmos ad=0.1406p pd=1.12u as=0.2516p ps=2.16u w=0.74u l=0.13u
X1 Y A a_154_118# VSS sg13_lv_nmos ad=0.2516p pd=2.16u as=0.1406p ps=1.12u w=0.74u l=0.13u
X2 Y B VDD VDD sg13_lv_pmos ad=0.2128p pd=1.5u as=0.3808p ps=2.92u w=1.12u l=0.13u
X3 VDD A Y VDD sg13_lv_pmos ad=0.3808p pd=2.92u as=0.2128p ps=1.5u w=1.12u l=0.13u
.ends

.subckt sg13g2_inv_1 Y A VSS VDD
X0 Y A VDD VDD sg13_lv_pmos ad=0.3808p pd=2.92u as=0.3808p ps=2.92u w=1.12u l=0.13u
X1 Y A VSS VSS sg13_lv_nmos ad=0.2516p pd=2.16u as=0.2516p ps=2.16u w=0.74u l=0.13u
.ends

.subckt sg13g2_nand2b_1 VSS A_N Y B VDD
X0 VDD A_N a_27_156# VDD sg13_lv_pmos ad=0.2198p pd=1.53u as=0.2856p ps=2.36u w=0.84u l=0.13u
X1 Y B VDD VDD sg13_lv_pmos ad=0.2128p pd=1.5u as=0.2198p ps=1.53u w=1.12u l=0.13u
X2 Y a_27_156# a_229_118# VSS sg13_lv_nmos ad=0.333p pd=2.38u as=0.1406p ps=1.12u w=0.74u l=0.13u
X3 VSS A_N a_27_156# VSS sg13_lv_nmos ad=0.14505p pd=1.15u as=0.187p ps=1.78u w=0.55u l=0.13u
X4 VDD a_27_156# Y VDD sg13_lv_pmos ad=0.3808p pd=2.92u as=0.2128p ps=1.5u w=1.12u l=0.13u
X5 a_229_118# B VSS VSS sg13_lv_nmos ad=0.1406p pd=1.12u as=0.14505p ps=1.15u w=0.74u l=0.13u
.ends

.subckt sg13g2_and2_1 X VSS VDD B A
X0 X a_45_160# VDD VDD sg13_lv_pmos ad=0.3808p pd=2.92u as=0.1918p ps=1.5u w=1.12u l=0.13u
X1 X a_45_160# VSS VSS sg13_lv_nmos ad=0.2516p pd=2.16u as=0.1331p ps=1.12u w=0.74u l=0.13u
X2 a_45_160# A VDD VDD sg13_lv_pmos ad=0.1596p pd=1.22u as=0.2856p ps=2.36u w=0.84u l=0.13u
X3 VDD B a_45_160# VDD sg13_lv_pmos ad=0.1918p pd=1.5u as=0.1596p ps=1.22u w=0.84u l=0.13u
X4 a_139_160# A a_45_160# VSS sg13_lv_nmos ad=0.1216p pd=1.02u as=0.2176p ps=1.96u w=0.64u l=0.13u
X5 VSS B a_139_160# VSS sg13_lv_nmos ad=0.1331p pd=1.12u as=0.1216p ps=1.02u w=0.64u l=0.13u
.ends

.subckt sg13g2_a221oi_1 C1 Y B2 B1 A2 VDD A1 VSS
X0 a_550_140# A1 Y VSS sg13_lv_nmos ad=0.1406p pd=1.12u as=0.2516p ps=2.16u w=0.74u l=0.13u
X1 VSS A2 a_550_140# VSS sg13_lv_nmos ad=0.2516p pd=2.16u as=0.1406p ps=1.12u w=0.74u l=0.13u
X2 a_142_412# C1 Y VDD sg13_lv_pmos ad=0.2128p pd=1.5u as=0.3808p ps=2.92u w=1.12u l=0.13u
X3 a_244_412# B2 a_142_412# VDD sg13_lv_pmos ad=0.2128p pd=1.5u as=0.2128p ps=1.5u w=1.12u l=0.13u
X4 a_142_412# B1 a_244_412# VDD sg13_lv_pmos ad=0.3808p pd=2.92u as=0.2128p ps=1.5u w=1.12u l=0.13u
X5 a_244_412# A1 VDD VDD sg13_lv_pmos ad=0.2128p pd=1.5u as=0.3808p ps=2.92u w=1.12u l=0.13u
X6 VDD A2 a_244_412# VDD sg13_lv_pmos ad=0.3808p pd=2.92u as=0.2128p ps=1.5u w=1.12u l=0.13u
X7 VSS C1 Y VSS sg13_lv_nmos ad=0.1406p pd=1.12u as=0.2516p ps=2.16u w=0.74u l=0.13u
X8 a_244_140# B2 VSS VSS sg13_lv_nmos ad=0.1406p pd=1.12u as=0.1406p ps=1.12u w=0.74u l=0.13u
X9 Y B1 a_244_140# VSS sg13_lv_nmos ad=0.2516p pd=2.16u as=0.1406p ps=1.12u w=0.74u l=0.13u
.ends

.subckt sg13g2_nor2b_1 A B_N VDD Y VSS
X0 VDD B_N a_46_156# VDD sg13_lv_pmos ad=0.2618p pd=1.63u as=0.2856p ps=2.36u w=0.84u l=0.13u
X1 VSS B_N a_46_156# VSS sg13_lv_nmos ad=0.17255p pd=1.25u as=0.187p ps=1.78u w=0.55u l=0.13u
X2 Y a_46_156# VSS VSS sg13_lv_nmos ad=0.1406p pd=1.12u as=0.17255p ps=1.25u w=0.74u l=0.13u
X3 a_268_412# a_46_156# VDD VDD sg13_lv_pmos ad=0.1176p pd=1.33u as=0.2618p ps=1.63u w=1.12u l=0.13u
X4 VSS A Y VSS sg13_lv_nmos ad=0.2516p pd=2.16u as=0.1406p ps=1.12u w=0.74u l=0.13u
X5 Y A a_268_412# VDD sg13_lv_pmos ad=0.3808p pd=2.92u as=0.1176p ps=1.33u w=1.12u l=0.13u
.ends

.subckt sg13g2_nor4_1 VSS VDD B C Y A D
X0 Y C VSS VSS sg13_lv_nmos ad=0.1406p pd=1.12u as=0.1406p ps=1.12u w=0.74u l=0.13u
X1 a_252_412# B a_150_412# VDD sg13_lv_pmos ad=0.2128p pd=1.5u as=0.2128p ps=1.5u w=1.12u l=0.13u
X2 VSS D Y VSS sg13_lv_nmos ad=0.23757p pd=2.16u as=0.1406p ps=1.12u w=0.74u l=0.13u
X3 a_354_412# C a_252_412# VDD sg13_lv_pmos ad=0.2128p pd=1.5u as=0.2128p ps=1.5u w=1.12u l=0.13u
X4 Y D a_354_412# VDD sg13_lv_pmos ad=0.4368p pd=3.02u as=0.2128p ps=1.5u w=1.12u l=0.13u
X5 Y A VSS VSS sg13_lv_nmos ad=0.1406p pd=1.12u as=0.2516p ps=2.16u w=0.74u l=0.13u
X6 VSS B Y VSS sg13_lv_nmos ad=0.1406p pd=1.12u as=0.1406p ps=1.12u w=0.74u l=0.13u
X7 a_150_412# A VDD VDD sg13_lv_pmos ad=0.2128p pd=1.5u as=0.3808p ps=2.92u w=1.12u l=0.13u
.ends

.subckt sg13g2_a22oi_1 Y A2 VDD B1 A1 VSS B2
X0 Y B2 a_127_96# VSS sg13_lv_nmos ad=0.2664p pd=1.46u as=0.13875p ps=1.115u w=0.74u l=0.13u
X1 a_398_96# A1 Y VSS sg13_lv_nmos ad=96.2f pd=1u as=0.2664p ps=1.46u w=0.74u l=0.13u
X2 VDD A2 a_127_436# VDD sg13_lv_pmos ad=0.3808p pd=2.92u as=0.2744p ps=1.61u w=1.12u l=0.13u
X3 Y B1 a_127_436# VDD sg13_lv_pmos ad=0.2128p pd=1.5u as=0.2716p ps=1.605u w=1.12u l=0.13u
X4 a_127_436# B2 Y VDD sg13_lv_pmos ad=0.2744p pd=1.61u as=0.2128p ps=1.5u w=1.12u l=0.13u
X5 a_127_96# B1 VSS VSS sg13_lv_nmos ad=0.13875p pd=1.115u as=0.2553p ps=2.17u w=0.74u l=0.13u
X6 a_127_436# A1 VDD VDD sg13_lv_pmos ad=0.2716p pd=1.605u as=0.3808p ps=2.92u w=1.12u l=0.13u
X7 VSS A2 a_398_96# VSS sg13_lv_nmos ad=0.2516p pd=2.16u as=96.2f ps=1u w=0.74u l=0.13u
.ends

.subckt sg13g2_nand4_1 VDD Y B C VSS A D
X0 Y A a_350_122# VSS sg13_lv_nmos ad=0.2516p pd=2.16u as=0.1406p ps=1.12u w=0.74u l=0.13u
X1 Y D VDD VDD sg13_lv_pmos ad=0.2128p pd=1.5u as=0.3808p ps=2.92u w=1.12u l=0.13u
X2 VDD C Y VDD sg13_lv_pmos ad=0.2128p pd=1.5u as=0.2128p ps=1.5u w=1.12u l=0.13u
X3 Y B VDD VDD sg13_lv_pmos ad=0.2128p pd=1.5u as=0.2128p ps=1.5u w=1.12u l=0.13u
X4 VDD A Y VDD sg13_lv_pmos ad=0.3808p pd=2.92u as=0.2128p ps=1.5u w=1.12u l=0.13u
X5 a_146_122# D VSS VSS sg13_lv_nmos ad=0.1406p pd=1.12u as=0.2516p ps=2.16u w=0.74u l=0.13u
X6 a_248_122# C a_146_122# VSS sg13_lv_nmos ad=0.1406p pd=1.12u as=0.1406p ps=1.12u w=0.74u l=0.13u
X7 a_350_122# B a_248_122# VSS sg13_lv_nmos ad=0.1406p pd=1.12u as=0.1406p ps=1.12u w=0.74u l=0.13u
.ends

.subckt sg13g2_and4_1 X B A VDD VSS C D
X0 VDD D a_81_118# VDD sg13_lv_pmos ad=0.2044p pd=1.53u as=0.1848p ps=1.28u w=0.84u l=0.13u
X1 a_175_118# A a_81_118# VSS sg13_lv_nmos ad=0.1216p pd=1.02u as=0.2176p ps=1.96u w=0.64u l=0.13u
X2 a_277_118# B a_175_118# VSS sg13_lv_nmos ad=0.1216p pd=1.02u as=0.1216p ps=1.02u w=0.64u l=0.13u
X3 a_379_118# C a_277_118# VSS sg13_lv_nmos ad=0.1408p pd=1.08u as=0.1216p ps=1.02u w=0.64u l=0.13u
X4 VSS D a_379_118# VSS sg13_lv_nmos ad=0.1447p pd=1.15u as=0.1408p ps=1.08u w=0.64u l=0.13u
X5 X a_81_118# VSS VSS sg13_lv_nmos ad=0.3552p pd=2.44u as=0.1447p ps=1.15u w=0.74u l=0.13u
X6 X a_81_118# VDD VDD sg13_lv_pmos ad=0.5376p pd=3.2u as=0.2044p ps=1.53u w=1.12u l=0.13u
X7 a_81_118# A VDD VDD sg13_lv_pmos ad=0.1596p pd=1.22u as=0.2856p ps=2.36u w=0.84u l=0.13u
X8 VDD B a_81_118# VDD sg13_lv_pmos ad=0.1596p pd=1.22u as=0.1596p ps=1.22u w=0.84u l=0.13u
X9 a_81_118# C VDD VDD sg13_lv_pmos ad=0.1848p pd=1.28u as=0.1596p ps=1.22u w=0.84u l=0.13u
.ends

.subckt sg13g2_mux2_1 A1 X S VDD VSS A0
X0 a_496_118# A0 a_382_118# VSS sg13_lv_nmos ad=0.3367p pd=1.65u as=0.1628p ps=1.18u w=0.74u l=0.13u
X1 a_382_118# A0 a_285_412# VDD sg13_lv_pmos ad=0.2225p pd=1.445u as=0.3325p ps=1.665u w=1u l=0.13u
X2 a_559_412# A1 a_382_118# VDD sg13_lv_pmos ad=0.2975p pd=1.595u as=0.2225p ps=1.445u w=1u l=0.13u
X3 VDD S a_59_156# VDD sg13_lv_pmos ad=0.253p pd=1.53u as=0.2856p ps=2.36u w=0.84u l=0.13u
X4 VSS S a_59_156# VSS sg13_lv_nmos ad=0.18945p pd=1.27u as=0.187p ps=1.78u w=0.55u l=0.13u
X5 X a_382_118# VSS VSS sg13_lv_nmos ad=0.4033p pd=2.57u as=0.148p ps=1.14u w=0.74u l=0.13u
X6 X a_382_118# VDD VDD sg13_lv_pmos ad=0.6048p pd=3.32u as=0.2198p ps=1.52u w=1.12u l=0.13u
X7 a_285_118# S VSS VSS sg13_lv_nmos ad=0.13135p pd=1.095u as=0.18945p ps=1.27u w=0.74u l=0.13u
X8 a_285_412# S VDD VDD sg13_lv_pmos ad=0.3325p pd=1.665u as=0.253p ps=1.53u w=1u l=0.13u
X9 VSS a_59_156# a_496_118# VSS sg13_lv_nmos ad=0.148p pd=1.14u as=0.3367p ps=1.65u w=0.74u l=0.13u
X10 a_382_118# A1 a_285_118# VSS sg13_lv_nmos ad=0.1628p pd=1.18u as=0.13135p ps=1.095u w=0.74u l=0.13u
X11 VDD a_59_156# a_559_412# VDD sg13_lv_pmos ad=0.2198p pd=1.52u as=0.2975p ps=1.595u w=1u l=0.13u
.ends

.subckt sg13g2_nor3_1 A Y B C VDD VSS
X0 Y A VSS VSS sg13_lv_nmos ad=0.1694p pd=1.21u as=0.2618p ps=2.22u w=0.77u l=0.13u
X1 a_165_412# A VDD VDD sg13_lv_pmos ad=0.2464p pd=1.56u as=0.3808p ps=2.92u w=1.12u l=0.13u
X2 VSS B Y VSS sg13_lv_nmos ad=0.1463p pd=1.15u as=0.1694p ps=1.21u w=0.77u l=0.13u
X3 Y C VSS VSS sg13_lv_nmos ad=0.2618p pd=2.22u as=0.1463p ps=1.15u w=0.77u l=0.13u
X4 a_279_412# B a_165_412# VDD sg13_lv_pmos ad=0.2128p pd=1.5u as=0.2464p ps=1.56u w=1.12u l=0.13u
X5 Y C a_279_412# VDD sg13_lv_pmos ad=0.3808p pd=2.92u as=0.2128p ps=1.5u w=1.12u l=0.13u
.ends

.subckt sg13g2_nand3b_1 A_N Y VDD VSS B C
X0 a_318_122# C VSS VSS sg13_lv_nmos ad=0.1406p pd=1.12u as=0.18575p ps=1.26u w=0.74u l=0.13u
X1 a_420_122# B a_318_122# VSS sg13_lv_nmos ad=0.1406p pd=1.12u as=0.1406p ps=1.12u w=0.74u l=0.13u
X2 Y a_94_160# a_420_122# VSS sg13_lv_nmos ad=0.3404p pd=2.4u as=0.1406p ps=1.12u w=0.74u l=0.13u
X3 VSS A_N a_94_160# VSS sg13_lv_nmos ad=0.18575p pd=1.26u as=0.187p ps=1.78u w=0.55u l=0.13u
X4 VDD A_N a_94_160# VDD sg13_lv_pmos ad=0.2198p pd=1.53u as=0.2856p ps=2.36u w=0.84u l=0.13u
X5 Y C VDD VDD sg13_lv_pmos ad=0.2128p pd=1.5u as=0.2198p ps=1.53u w=1.12u l=0.13u
X6 VDD B Y VDD sg13_lv_pmos ad=0.2128p pd=1.5u as=0.2128p ps=1.5u w=1.12u l=0.13u
X7 Y a_94_160# VDD VDD sg13_lv_pmos ad=0.3808p pd=2.92u as=0.2128p ps=1.5u w=1.12u l=0.13u
.ends

.subckt sg13g2_nand3_1 VDD Y B C A VSS
X0 Y C VDD VDD sg13_lv_pmos ad=0.2128p pd=1.5u as=0.3808p ps=2.92u w=1.12u l=0.13u
X1 VDD B Y VDD sg13_lv_pmos ad=0.2128p pd=1.5u as=0.2128p ps=1.5u w=1.12u l=0.13u
X2 Y A VDD VDD sg13_lv_pmos ad=0.3808p pd=2.92u as=0.2128p ps=1.5u w=1.12u l=0.13u
X3 a_146_122# C VSS VSS sg13_lv_nmos ad=0.1406p pd=1.12u as=0.2886p ps=2.26u w=0.74u l=0.13u
X4 a_248_122# B a_146_122# VSS sg13_lv_nmos ad=0.1406p pd=1.12u as=0.1406p ps=1.12u w=0.74u l=0.13u
X5 Y A a_248_122# VSS sg13_lv_nmos ad=0.2516p pd=2.16u as=0.1406p ps=1.12u w=0.74u l=0.13u
.ends

.subckt sg13g2_a21o_1 B1 X VDD VSS A1 A2
X0 VSS a_115_308# X VSS sg13_lv_nmos ad=0.15745p pd=1.175u as=0.2351p ps=2.16u w=0.74u l=0.13u
X1 VDD A1 a_358_436# VDD sg13_lv_pmos ad=0.19p pd=1.38u as=0.2125p ps=1.425u w=1u l=0.13u
X2 VSS A2 a_494_160# VSS sg13_lv_nmos ad=0.2176p pd=1.96u as=81.6f ps=0.895u w=0.64u l=0.13u
X3 a_358_436# A2 VDD VDD sg13_lv_pmos ad=0.34p pd=2.68u as=0.19p ps=1.38u w=1u l=0.13u
X4 a_115_308# B1 VSS VSS sg13_lv_nmos ad=0.1216p pd=1.02u as=0.15745p ps=1.175u w=0.64u l=0.13u
X5 a_494_160# A1 a_115_308# VSS sg13_lv_nmos ad=81.6f pd=0.895u as=0.1216p ps=1.02u w=0.64u l=0.13u
X6 a_358_436# B1 a_115_308# VDD sg13_lv_pmos ad=0.2125p pd=1.425u as=0.35p ps=2.7u w=1u l=0.13u
X7 VDD a_115_308# X VDD sg13_lv_pmos ad=0.3808p pd=2.92u as=0.3808p ps=2.92u w=1.12u l=0.13u
.ends

.subckt sg13g2_and3_1 X B VDD VSS C A
X0 a_170_160# A a_76_160# VSS sg13_lv_nmos ad=0.1216p pd=1.02u as=0.2176p ps=1.96u w=0.64u l=0.13u
X1 a_272_160# B a_170_160# VSS sg13_lv_nmos ad=0.1216p pd=1.02u as=0.1216p ps=1.02u w=0.64u l=0.13u
X2 VSS C a_272_160# VSS sg13_lv_nmos ad=0.1371p pd=1.12u as=0.1216p ps=1.02u w=0.64u l=0.13u
X3 VDD A a_76_160# VDD sg13_lv_pmos ad=0.1596p pd=1.22u as=0.2856p ps=2.36u w=0.84u l=0.13u
X4 a_76_160# B VDD VDD sg13_lv_pmos ad=0.1596p pd=1.22u as=0.1596p ps=1.22u w=0.84u l=0.13u
X5 VDD C a_76_160# VDD sg13_lv_pmos ad=0.36195p pd=1.84u as=0.1596p ps=1.22u w=0.84u l=0.13u
X6 X a_76_160# VDD VDD sg13_lv_pmos ad=0.3808p pd=2.92u as=0.36195p ps=1.84u w=1.12u l=0.13u
X7 X a_76_160# VSS VSS sg13_lv_nmos ad=0.2516p pd=2.16u as=0.1371p ps=1.12u w=0.74u l=0.13u
.ends

.subckt sg13g2_xor2_1 X VDD B A VSS
X0 X B a_474_130# VSS sg13_lv_nmos ad=0.1628p pd=1.18u as=88.8f ps=0.98u w=0.74u l=0.13u
X1 VSS a_209_168# X VSS sg13_lv_nmos ad=0.3108p pd=2.32u as=0.1628p ps=1.18u w=0.74u l=0.13u
X2 VDD A a_380_412# VDD sg13_lv_pmos ad=0.2128p pd=1.5u as=0.3808p ps=2.92u w=1.12u l=0.13u
X3 a_380_412# B VDD VDD sg13_lv_pmos ad=0.2128p pd=1.5u as=0.2128p ps=1.5u w=1.12u l=0.13u
X4 X a_209_168# a_380_412# VDD sg13_lv_pmos ad=0.3808p pd=2.92u as=0.2128p ps=1.5u w=1.12u l=0.13u
X5 a_177_436# A VDD VDD sg13_lv_pmos ad=0.1225p pd=1.245u as=0.36p ps=2.72u w=1u l=0.13u
X6 a_209_168# A VSS VSS sg13_lv_nmos ad=0.17462p pd=1.185u as=0.374p ps=2.46u w=0.55u l=0.13u
X7 a_209_168# B a_177_436# VDD sg13_lv_pmos ad=0.34p pd=2.68u as=0.1225p ps=1.245u w=1u l=0.13u
X8 VSS B a_209_168# VSS sg13_lv_nmos ad=0.15245p pd=1.17u as=0.17462p ps=1.185u w=0.55u l=0.13u
X9 a_474_130# A VSS VSS sg13_lv_nmos ad=88.8f pd=0.98u as=0.15245p ps=1.17u w=0.74u l=0.13u
.ends

.subckt sg13g2_or4_1 X C D VDD VSS A B
X0 a_72_436# B VSS VSS sg13_lv_nmos ad=0.1045p pd=0.93u as=0.16755p ps=1.165u w=0.55u l=0.13u
X1 VSS A a_72_436# VSS sg13_lv_nmos ad=0.14135p pd=1.14u as=0.1045p ps=0.93u w=0.55u l=0.13u
X2 a_166_436# D a_72_436# VDD sg13_lv_pmos ad=0.19p pd=1.38u as=0.34p ps=2.68u w=1u l=0.13u
X3 a_268_436# C a_166_436# VDD sg13_lv_pmos ad=0.2925p pd=1.585u as=0.19p ps=1.38u w=1u l=0.13u
X4 X a_72_436# VSS VSS sg13_lv_nmos ad=0.2516p pd=2.16u as=0.14135p ps=1.14u w=0.74u l=0.13u
X5 a_411_436# B a_268_436# VDD sg13_lv_pmos ad=0.19p pd=1.38u as=0.2925p ps=1.585u w=1u l=0.13u
X6 a_72_436# D VSS VSS sg13_lv_nmos ad=0.1045p pd=0.93u as=0.187p ps=1.78u w=0.55u l=0.13u
X7 X a_72_436# VDD VDD sg13_lv_pmos ad=0.3808p pd=2.92u as=0.2144p ps=1.52u w=1.12u l=0.13u
X8 VDD A a_411_436# VDD sg13_lv_pmos ad=0.2144p pd=1.52u as=0.19p ps=1.38u w=1u l=0.13u
X9 VSS C a_72_436# VSS sg13_lv_nmos ad=0.16755p pd=1.165u as=0.1045p ps=0.93u w=0.55u l=0.13u
.ends

.subckt sg13g2_or3_1 VDD VSS C B A X
X0 VSS A a_73_118# VSS sg13_lv_nmos ad=0.13395p pd=1.12u as=0.198p ps=1.27u w=0.55u l=0.13u
X1 X a_73_118# VSS VSS sg13_lv_nmos ad=0.2516p pd=2.16u as=0.13395p ps=1.12u w=0.74u l=0.13u
X2 VDD A a_269_412# VDD sg13_lv_pmos ad=0.3822p pd=1.84u as=0.1575p ps=1.315u w=1u l=0.13u
X3 VSS C a_73_118# VSS sg13_lv_nmos ad=0.1045p pd=0.93u as=0.187p ps=1.78u w=0.55u l=0.13u
X4 a_167_412# C a_73_118# VDD sg13_lv_pmos ad=0.19p pd=1.38u as=0.34p ps=2.68u w=1u l=0.13u
X5 X a_73_118# VDD VDD sg13_lv_pmos ad=0.3808p pd=2.92u as=0.3822p ps=1.84u w=1.12u l=0.13u
X6 a_73_118# B VSS VSS sg13_lv_nmos ad=0.198p pd=1.27u as=0.1045p ps=0.93u w=0.55u l=0.13u
X7 a_269_412# B a_167_412# VDD sg13_lv_pmos ad=0.1575p pd=1.315u as=0.19p ps=1.38u w=1u l=0.13u
.ends

.subckt tt_um_italu VDD VSS clk ena rst_n ui_in[0] ui_in[1] ui_in[2] ui_in[3] ui_in[4]
+ ui_in[5] ui_in[6] ui_in[7] uio_in[0] uio_in[1] uio_in[2] uio_in[3] uio_in[4] uio_in[5]
+ uio_in[6] uio_in[7] uio_oe[0] uio_oe[1] uio_oe[2] uio_oe[3] uio_oe[4] uio_oe[5]
+ uio_oe[6] uio_oe[7] uio_out[0] uio_out[1] uio_out[2] uio_out[3] uio_out[4] uio_out[5]
+ uio_out[6] uio_out[7] uo_out[0] uo_out[1] uo_out[2] uo_out[3] uo_out[4] uo_out[5]
+ uo_out[6] uo_out[7]
Xscan_reg\[41\]_sg13g2_nor2_1_A scan_reg\[41\]_sg13g2_nor2_1_A/A VDD scan_reg\[41\]_sg13g2_nor2_1_A/Y
+ VSS scan_reg\[41\]_sg13g2_nor2_1_A/B sg13g2_nor2_1
Xscan_reg\[41\]_sg13g2_a21oi_1_A1_Y_sg13g2_a21oi_1_B1 VDD VSS bist_done_sg13g2_inv_1_A/Y
+ ui_in[3] scan_reg\[41\]_sg13g2_a21oi_1_A1/Y scan_reg\[40\]_sg13g2_a21o_1_A1/B1 sg13g2_a21oi_1
Xuo_out_sg13g2_dfrbpq_1_Q_4_D_sg13g2_a21oi_1_Y VDD VSS uo_out_sg13g2_dfrbpq_1_Q_4_D_sg13g2_a21oi_1_Y/A2
+ ui_in[2] uo_out_sg13g2_dfrbpq_1_Q_4_D_sg13g2_a21oi_1_Y/B1 uo_out_sg13g2_dfrbpq_1_Q_4/D
+ sg13g2_a21oi_1
Xcycle_counter\[6\]_sg13g2_dfrbpq_1_Q_D_sg13g2_xnor2_1_Y cycle_counter\[6\]_sg13g2_dfrbpq_1_Q/D
+ cycle_counter\[5\]_sg13g2_dfrbpq_1_Q_D_sg13g2_and2_1_X/A VDD cycle_counter\[6\]_sg13g2_dfrbpq_1_Q/Q
+ VSS sg13g2_xnor2_1
Xscan_reg\[20\]_sg13g2_dfrbpq_1_Q VDD scan_reg\[20\]_sg13g2_dfrbpq_1_Q/D scan_reg\[20\]_sg13g2_inv_1_A/A
+ clkbuf_5_31__f_clk/X VSS rst_n sg13g2_dfrbpq_1
Xmisr\[4\]_sg13g2_dfrbpq_1_Q_D_sg13g2_a22oi_1_Y_B2_sg13g2_o21ai_1_Y_B1_sg13g2_a21oi_1_Y
+ VDD VSS misr\[4\]_sg13g2_dfrbpq_1_Q_D_sg13g2_a22oi_1_Y_B2_sg13g2_o21ai_1_Y/A2 misr\[3\]_sg13g2_dfrbpq_1_Q/Q
+ bist_state\[1\]_sg13g2_inv_1_A/Y misr\[4\]_sg13g2_dfrbpq_1_Q_D_sg13g2_a22oi_1_Y_B2_sg13g2_o21ai_1_Y/B1
+ sg13g2_a21oi_1
Xoverflow_flag_sg13g2_dfrbpq_1_Q_D_sg13g2_inv_1_Y_A_sg13g2_o21ai_1_Y_B1_sg13g2_nand3_1_Y_A_sg13g2_and4_1_A_X_sg13g2_nand3_1_B_A_sg13g2_or2_1_X
+ overflow_flag_sg13g2_dfrbpq_1_Q_D_sg13g2_inv_1_Y_A_sg13g2_o21ai_1_Y_B1_sg13g2_nand3_1_Y_A_sg13g2_and4_1_A_X_sg13g2_nand3_1_B_A_sg13g2_or2_1_X/A
+ VSS overflow_flag_sg13g2_dfrbpq_1_Q_D_sg13g2_inv_1_Y_A_sg13g2_o21ai_1_Y_B1_sg13g2_nand3_1_Y_A_sg13g2_and4_1_A_X_sg13g2_nand3_1_B_A_sg13g2_or2_1_X/B
+ overflow_flag_sg13g2_dfrbpq_1_Q_D_sg13g2_inv_1_Y_A_sg13g2_o21ai_1_Y_B1_sg13g2_nand3_1_Y_A_sg13g2_and4_1_A_X_sg13g2_nand3_1_B/A
+ VDD sg13g2_or2_1
Xscan_reg\[29\]_sg13g2_dfrbpq_1_Q_D_sg13g2_o21ai_1_Y VSS VDD scan_reg\[29\]_sg13g2_dfrbpq_1_Q/D
+ scan_reg\[30\]_sg13g2_a22oi_1_B2/Y scan_reg\[41\]_sg13g2_nor2_1_A/B scan_reg\[29\]_sg13g2_inv_1_A/Y
+ sg13g2_o21ai_1
Xscan_reg\[40\]_sg13g2_dfrbpq_1_Q VDD scan_reg\[40\]_sg13g2_a21o_1_A1/X scan_reg\[40\]_sg13g2_dfrbpq_1_Q/Q
+ clkload2/A VSS rst_n sg13g2_dfrbpq_1
Xclkbuf_4_12_0_clk clkbuf_4_12_0_clk/X VSS clkbuf_0_clk/X VDD sg13g2_buf_4
Xmisr\[1\]_sg13g2_dfrbpq_1_Q_D_sg13g2_a22oi_1_Y_B2_sg13g2_o21ai_1_Y_A2_sg13g2_a22oi_1_Y_B2_sg13g2_a21oi_1_Y_B1_sg13g2_nand2_1_Y
+ misr\[1\]_sg13g2_dfrbpq_1_Q_D_sg13g2_a22oi_1_Y_B2_sg13g2_o21ai_1_Y_A2_sg13g2_a22oi_1_Y_B2_sg13g2_a21oi_1_Y/B1
+ VDD uo_out_sg13g2_dfrbpq_1_Q_4_D_sg13g2_a21oi_1_Y_A2_sg13g2_a21o_1_X_A2_sg13g2_a21o_1_X/A1
+ VSS uo_out_sg13g2_dfrbpq_1_Q_2_D_sg13g2_o21ai_1_Y_B1_sg13g2_nand3_1_Y_C_sg13g2_nand3_1_Y_B_sg13g2_or2_1_X/B
+ sg13g2_nand2_1
Xlfsr\[1\]_sg13g2_a22oi_1_A1_B2_sg13g2_inv_1_Y lfsr\[1\]_sg13g2_a22oi_1_A1/B2 lfsr\[1\]_sg13g2_a22oi_1_A1_B2_sg13g2_inv_1_Y/A
+ VSS VDD sg13g2_inv_1
Xserial_b\[5\]_sg13g2_nand2b_1_B VSS serial_a\[5\]_sg13g2_dfrbpq_1_Q/Q serial_b\[5\]_sg13g2_nand2b_1_B/Y
+ serial_b\[5\]_sg13g2_nand2b_1_B/B VDD sg13g2_nand2b_1
Xscan_reg\[56\]_sg13g2_o21ai_1_A1 VSS VDD scan_reg\[56\]_sg13g2_o21ai_1_A1/Y scan_reg\[56\]_sg13g2_o21ai_1_A1/B1
+ scan_reg\[41\]_sg13g2_nor2_1_A/B scan_reg\[56\]_sg13g2_inv_1_A/A sg13g2_o21ai_1
Xserial_b\[4\]_sg13g2_dfrbpq_1_Q VDD serial_b\[4\]_sg13g2_dfrbpq_1_Q/D serial_b\[4\]_sg13g2_nand2_1_A/A
+ clkload3/A VSS rst_n sg13g2_dfrbpq_1
Xcarry_flag_sg13g2_o21ai_1_A1_B1_sg13g2_nand2_1_Y_A_sg13g2_nand3_1_Y_A_sg13g2_nand2b_1_Y
+ VSS serial_a\[7\]_sg13g2_dfrbpq_1_Q/Q carry_flag_sg13g2_o21ai_1_A1_B1_sg13g2_nand2_1_Y_A_sg13g2_nand3_1_Y/A
+ serial_b\[7\]_sg13g2_dfrbpq_1_Q/Q VDD sg13g2_nand2b_1
Xscan_reg\[55\]_sg13g2_dfrbpq_1_Q_D_sg13g2_a21oi_1_Y VDD VSS scan_out_sg13g2_a22oi_1_A1/B1
+ scan_reg\[56\]_sg13g2_inv_1_A/Y scan_reg\[55\]_sg13g2_o21ai_1_A1/Y scan_reg\[55\]_sg13g2_dfrbpq_1_Q/D
+ sg13g2_a21oi_1
Xoperand_b\[0\]_sg13g2_nand2b_1_A_N VSS operand_b\[0\]_sg13g2_mux2_1_A0/A0 scan_reg\[8\]_sg13g2_o21ai_1_A1_1/B1
+ ui_in[3] VDD sg13g2_nand2b_1
Xbist_a\[7\]_sg13g2_dfrbpq_1_Q_D_sg13g2_o21ai_1_Y_A1_sg13g2_nand2_1_A_Y_sg13g2_a221oi_1_B2_A2_sg13g2_xnor2_1_Y_B_sg13g2_and2_1_X
+ bist_a\[7\]_sg13g2_dfrbpq_1_Q_D_sg13g2_o21ai_1_Y_A1_sg13g2_nand2_1_A_Y_sg13g2_a221oi_1_B2_A2_sg13g2_xnor2_1_Y/B
+ VSS VDD misr\[1\]_sg13g2_inv_1_A_Y_sg13g2_xnor2_1_A_B_sg13g2_o21ai_1_Y_A2_sg13g2_nand3_1_Y_C_sg13g2_a22oi_1_Y_B1_sg13g2_and2_1_X/A
+ bist_a\[7\]_sg13g2_dfrbpq_1_Q_D_sg13g2_o21ai_1_Y_A1_sg13g2_nand2_1_A_Y_sg13g2_a221oi_1_B2_A2_sg13g2_xnor2_1_Y_B_sg13g2_and2_1_X/A
+ sg13g2_and2_1
Xscan_reg\[53\]_sg13g2_dfrbpq_1_Q_D_sg13g2_a221oi_1_Y_A1_sg13g2_nor2_1_A scan_reg\[53\]_sg13g2_dfrbpq_1_Q_D_sg13g2_a221oi_1_Y/A1
+ VDD cycle_counter\[4\]_sg13g2_dfrbpq_1_Q_D_sg13g2_xnor2_1_Y/B VSS cycle_counter\[2\]_sg13g2_dfrbpq_1_Q_D_sg13g2_and2_1_X/A
+ sg13g2_nor2_1
Xcarry_flag_sg13g2_o21ai_1_A1_B1_sg13g2_nand2_1_Y carry_flag_sg13g2_o21ai_1_A1/B1
+ VDD carry_flag_sg13g2_o21ai_1_A1_B1_sg13g2_nand2_1_Y/A VSS carry_flag_sg13g2_o21ai_1_A1_B1_sg13g2_nand2_1_Y/B
+ sg13g2_nand2_1
Xscan_reg\[52\]_sg13g2_dfrbpq_1_Q_D_sg13g2_a221oi_1_Y scan_reg\[53\]_sg13g2_nor2_1_A/Y
+ scan_reg\[52\]_sg13g2_dfrbpq_1_Q/D scan_out_sg13g2_a22oi_1_A1/A2 scan_reg\[52\]_sg13g2_inv_1_A/Y
+ ui_in[3] VDD scan_reg\[52\]_sg13g2_dfrbpq_1_Q_D_sg13g2_a221oi_1_Y/A1 VSS sg13g2_a221oi_1
Xscan_reg\[8\]_sg13g2_o21ai_1_A1 VSS VDD scan_reg\[8\]_sg13g2_o21ai_1_A1/Y scan_reg\[8\]_sg13g2_o21ai_1_A1/B1
+ scan_reg\[3\]_sg13g2_nor2_1_A/B scan_reg\[8\]_sg13g2_dfrbpq_1_Q/Q sg13g2_o21ai_1
Xuo_out_sg13g2_dfrbpq_1_Q_4_D_sg13g2_a21oi_1_Y_A2_sg13g2_a21o_1_X_A1_sg13g2_a22oi_1_Y_A1_sg13g2_nor2b_1_Y
+ uio_in[1] uio_in[2] VDD uo_out_sg13g2_dfrbpq_1_Q_5_D_sg13g2_a21oi_1_Y_A2_sg13g2_o21ai_1_Y_A2_sg13g2_mux2_1_X/A0
+ VSS sg13g2_nor2b_1
Xmisr\[4\]_sg13g2_inv_1_A_Y_sg13g2_xnor2_1_A_B_sg13g2_o21ai_1_Y_B1_sg13g2_or2_1_X_A_sg13g2_nand3_1_Y_B_sg13g2_a22oi_1_Y_B1_sg13g2_o21ai_1_Y
+ VSS VDD misr\[4\]_sg13g2_inv_1_A_Y_sg13g2_xnor2_1_A_B_sg13g2_o21ai_1_Y_B1_sg13g2_or2_1_X_A_sg13g2_nand3_1_Y_B_sg13g2_a22oi_1_Y/B1
+ misr\[4\]_sg13g2_inv_1_A_Y_sg13g2_xnor2_1_A_B_sg13g2_o21ai_1_Y_B1_sg13g2_or2_1_X_A_sg13g2_nand3_1_Y_B_sg13g2_a22oi_1_Y_B1_sg13g2_o21ai_1_Y/B1
+ bist_a\[7\]_sg13g2_dfrbpq_1_Q_D_sg13g2_o21ai_1_Y_A1_sg13g2_o21ai_1_A1_Y_sg13g2_nand2b_1_A_N_Y_sg13g2_a221oi_1_C1_B1_sg13g2_mux2_1_X/S
+ bist_a\[1\]_sg13g2_dfrbpq_1_Q_D_sg13g2_o21ai_1_Y/A1 sg13g2_o21ai_1
Xuo_out_sg13g2_dfrbpq_1_Q_2_D_sg13g2_o21ai_1_Y VSS VDD uo_out_sg13g2_dfrbpq_1_Q_2/D
+ uo_out_sg13g2_dfrbpq_1_Q_2_D_sg13g2_o21ai_1_Y/B1 ui_in[2] uo_out_sg13g2_dfrbpq_1_Q_2_D_sg13g2_o21ai_1_Y/A1
+ sg13g2_o21ai_1
Xuo_out_sg13g2_dfrbpq_1_Q_3_D_sg13g2_o21ai_1_Y_B1_sg13g2_nand2_1_Y_B_sg13g2_a22oi_1_Y_A1_sg13g2_a221oi_1_Y_C1_sg13g2_or4_1_X_C_sg13g2_nor4_1_Y
+ VSS VDD serial_opcode\[2\]_sg13g2_nor3_1_A/C serial_opcode\[3\]_sg13g2_nand2_1_B/Y
+ uo_out_sg13g2_dfrbpq_1_Q_3_D_sg13g2_o21ai_1_Y_B1_sg13g2_nand2_1_Y_B_sg13g2_a22oi_1_Y_A1_sg13g2_a221oi_1_Y_C1_sg13g2_or4_1_X/C
+ carry_flag_sg13g2_o21ai_1_A1_B1_sg13g2_nand2_1_Y_A_sg13g2_nand3_1_Y_B_sg13g2_nand3_1_C_A_sg13g2_o21ai_1_B1/A1
+ uo_out_sg13g2_dfrbpq_1_Q_3_D_sg13g2_o21ai_1_Y_B1_sg13g2_nand2_1_Y_B_sg13g2_a22oi_1_Y_A1_sg13g2_a221oi_1_Y_C1_sg13g2_or4_1_X_C_sg13g2_nor4_1_Y/D
+ sg13g2_nor4_1
Xclkbuf_5_17__f_clk clkload3/A VSS clkbuf_4_8_0_clk/X VDD sg13g2_buf_4
Xmisr\[4\]_sg13g2_dfrbpq_1_Q_D_sg13g2_a22oi_1_Y_B2_sg13g2_o21ai_1_Y_A2_sg13g2_a21oi_1_Y
+ VDD VSS uo_out_sg13g2_dfrbpq_1_Q_6_D_sg13g2_a21oi_1_Y_A2_sg13g2_a21o_1_X/A1 misr\[4\]_sg13g2_inv_1_A_Y_sg13g2_xnor2_1_A_B_sg13g2_o21ai_1_Y_A1_sg13g2_a21oi_1_Y/A2
+ misr\[4\]_sg13g2_dfrbpq_1_Q_D_sg13g2_a22oi_1_Y_B2_sg13g2_o21ai_1_Y_A2_sg13g2_a21oi_1_Y/B1
+ misr\[4\]_sg13g2_dfrbpq_1_Q_D_sg13g2_a22oi_1_Y_B2_sg13g2_o21ai_1_Y/A2 sg13g2_a21oi_1
Xuio_out_sg13g2_nand2_1_Y_4_A_sg13g2_a22oi_1_Y uio_out_sg13g2_nand2_1_Y_4/A bist_done_sg13g2_a22oi_1_B2/A2
+ VDD misr\[1\]_sg13g2_a22oi_1_B2/A2 cycle_counter\[0\]_sg13g2_dfrbpq_1_Q/Q VSS zero_flag_sg13g2_nand2_1_A/A
+ sg13g2_a22oi_1
Xbist_a\[7\]_sg13g2_dfrbpq_1_Q_D_sg13g2_o21ai_1_Y_A1_sg13g2_o21ai_1_A1_B1_sg13g2_nand4_1_C
+ VDD bist_a\[7\]_sg13g2_dfrbpq_1_Q_D_sg13g2_o21ai_1_Y_A1_sg13g2_o21ai_1_A1_B1_sg13g2_nand4_1_C/Y
+ bist_a\[7\]_sg13g2_dfrbpq_1_Q_D_sg13g2_o21ai_1_Y_A1_sg13g2_o21ai_1_A1_B1_sg13g2_nand4_1_C/B
+ bist_a\[7\]_sg13g2_dfrbpq_1_Q_D_sg13g2_o21ai_1_Y_A1_sg13g2_o21ai_1_A1/B1 VSS bist_a\[7\]_sg13g2_dfrbpq_1_Q_D_sg13g2_o21ai_1_Y_A1_sg13g2_o21ai_1_A1/A2
+ bist_a\[7\]_sg13g2_dfrbpq_1_Q_D_sg13g2_o21ai_1_Y_A1_sg13g2_o21ai_1_A1_B1_sg13g2_nand4_1_C/D
+ sg13g2_nand4_1
Xscan_reg\[37\]_sg13g2_a22oi_1_B1 scan_reg\[37\]_sg13g2_a22oi_1_B1/Y ui_in[3] VDD
+ scan_reg\[37\]_sg13g2_inv_1_A/A misr\[4\]_sg13g2_inv_1_A/A VSS scan_out_sg13g2_a22oi_1_A1/B1
+ sg13g2_a22oi_1
Xmisr\[1\]_sg13g2_dfrbpq_1_Q VDD misr\[1\]_sg13g2_dfrbpq_1_Q/D misr\[1\]_sg13g2_inv_1_A/A
+ clkbuf_5_13__f_clk/X VSS rst_n sg13g2_dfrbpq_1
Xmisr\[4\]_sg13g2_inv_1_A_Y_sg13g2_xnor2_1_A_B_sg13g2_o21ai_1_Y_A1_sg13g2_a21oi_1_Y_A2_sg13g2_a21oi_1_Y
+ VDD VSS misr\[4\]_sg13g2_inv_1_A_Y_sg13g2_xnor2_1_A_B_sg13g2_o21ai_1_Y_A1_sg13g2_a21oi_1_Y_A2_sg13g2_a21oi_1_Y/A2
+ misr\[4\]_sg13g2_inv_1_A_Y_sg13g2_xnor2_1_A_B_sg13g2_o21ai_1_Y_A1_sg13g2_a21oi_1_Y_A2_sg13g2_a21oi_1_Y/A1
+ misr\[4\]_sg13g2_inv_1_A_Y_sg13g2_xnor2_1_A_B_sg13g2_o21ai_1_Y_A1_sg13g2_a21oi_1_Y_A2_sg13g2_a21oi_1_Y/B1
+ misr\[4\]_sg13g2_inv_1_A_Y_sg13g2_xnor2_1_A_B_sg13g2_o21ai_1_Y_A1_sg13g2_a21oi_1_Y/A2
+ sg13g2_a21oi_1
Xmisr\[4\]_sg13g2_inv_1_A_Y_sg13g2_xnor2_1_A_B_sg13g2_o21ai_1_Y_B1_sg13g2_or2_1_X
+ misr\[4\]_sg13g2_inv_1_A_Y_sg13g2_xnor2_1_A_B_sg13g2_o21ai_1_Y_B1_sg13g2_or2_1_X/A
+ VSS misr\[4\]_sg13g2_inv_1_A_Y_sg13g2_xnor2_1_A_B_sg13g2_o21ai_1_Y_B1_sg13g2_or2_1_X/B
+ misr\[4\]_sg13g2_inv_1_A_Y_sg13g2_xnor2_1_A_B_sg13g2_o21ai_1_Y/B1 VDD sg13g2_or2_1
Xoperation\[3\]_sg13g2_dfrbpq_1_Q VDD operation\[3\]_sg13g2_dfrbpq_1_Q/D operation\[3\]_sg13g2_nor2_1_A/A
+ clkbuf_5_31__f_clk/X VSS rst_n sg13g2_dfrbpq_1
Xscan_reg\[32\]_sg13g2_o21ai_1_A1_B1_sg13g2_nand2b_1_Y VSS overflow_flag_sg13g2_dfrbpq_1_Q/Q
+ scan_reg\[32\]_sg13g2_o21ai_1_A1/B1 ui_in[3] VDD sg13g2_nand2b_1
Xlfsr\[6\]_sg13g2_dfrbpq_1_Q_D_sg13g2_inv_1_Y lfsr\[6\]_sg13g2_dfrbpq_1_Q/D lfsr\[6\]_sg13g2_a22oi_1_A1/Y
+ VSS VDD sg13g2_inv_1
Xuo_out_sg13g2_dfrbpq_1_Q_D_sg13g2_a21oi_1_Y_B1_sg13g2_a21oi_1_Y_A1_sg13g2_nand3_1_Y_B_sg13g2_a221oi_1_Y_C1_sg13g2_o21ai_1_Y
+ VSS VDD uo_out_sg13g2_dfrbpq_1_Q_D_sg13g2_a21oi_1_Y_B1_sg13g2_a21oi_1_Y_A1_sg13g2_nand3_1_Y_B_sg13g2_a221oi_1_Y/C1
+ carry_flag_sg13g2_o21ai_1_A1_B1_sg13g2_nand2_1_Y_A_sg13g2_nand3_1_Y_A_sg13g2_a21oi_1_B1_Y_sg13g2_a221oi_1_B2/Y
+ uo_out_sg13g2_dfrbpq_1_Q_D_sg13g2_a21oi_1_Y_B1_sg13g2_a21oi_1_Y_A1_sg13g2_nand3_1_Y_B_sg13g2_a221oi_1_Y_C1_sg13g2_o21ai_1_Y/A2
+ uo_out_sg13g2_dfrbpq_1_Q_D_sg13g2_a21oi_1_Y_B1_sg13g2_a21oi_1_Y_A1_sg13g2_nand3_1_Y_B_sg13g2_a221oi_1_Y_C1_sg13g2_o21ai_1_Y/A1
+ sg13g2_o21ai_1
Xbist_pattern_count\[3\]_sg13g2_nor2_1_A_B_sg13g2_and2_1_X bist_pattern_count\[3\]_sg13g2_nor2_1_A/B
+ VSS VDD bist_pattern_count\[1\]_sg13g2_and3_1_A/X bist_pattern_count\[3\]_sg13g2_nand4_1_D/C
+ sg13g2_and2_1
Xscan_reg\[13\]_sg13g2_dfrbpq_1_Q VDD scan_reg\[13\]_sg13g2_dfrbpq_1_Q/D scan_reg\[13\]_sg13g2_nor2_1_A/A
+ clkbuf_5_23__f_clk/X VSS rst_n sg13g2_dfrbpq_1
Xmisr\[6\]_sg13g2_dfrbpq_1_Q_D_sg13g2_o21ai_1_Y_A2_sg13g2_xnor2_1_Y_B_sg13g2_a22oi_1_Y_A1_sg13g2_and4_1_X
+ misr\[6\]_sg13g2_dfrbpq_1_Q_D_sg13g2_o21ai_1_Y_A2_sg13g2_xnor2_1_Y_B_sg13g2_a22oi_1_Y/A1
+ misr\[6\]_sg13g2_dfrbpq_1_Q_D_sg13g2_o21ai_1_Y_A2_sg13g2_xnor2_1_Y_B_sg13g2_a22oi_1_Y_A1_sg13g2_and4_1_X/B
+ misr\[6\]_sg13g2_dfrbpq_1_Q_D_sg13g2_o21ai_1_Y_A2_sg13g2_xnor2_1_Y_B_sg13g2_a22oi_1_Y_A1_sg13g2_and4_1_X/A
+ VDD VSS misr\[6\]_sg13g2_dfrbpq_1_Q_D_sg13g2_o21ai_1_Y_A2_sg13g2_xnor2_1_Y_B_sg13g2_a22oi_1_Y_A1_sg13g2_and4_1_X/C
+ misr\[6\]_sg13g2_dfrbpq_1_Q_D_sg13g2_o21ai_1_Y_A2_sg13g2_xnor2_1_Y_B_sg13g2_a22oi_1_Y_A1_sg13g2_and4_1_X/D
+ sg13g2_and4_1
Xuo_out_sg13g2_dfrbpq_1_Q_D_sg13g2_a21oi_1_Y_B1_sg13g2_a21oi_1_Y_A1_sg13g2_nand3_1_Y_B_sg13g2_a221oi_1_Y_C1_sg13g2_o21ai_1_Y_A1_sg13g2_nor2_1_B_Y_sg13g2_a22oi_1_B2_B1_sg13g2_nand3_1_Y_C_sg13g2_a21oi_1_A2_Y_sg13g2_nor2_1_B
+ serial_b\[6\]_sg13g2_and2_1_A/X VDD carry_flag_sg13g2_o21ai_1_A1_B1_sg13g2_nand2_1_Y_B_sg13g2_a21oi_1_Y_A2_sg13g2_a21oi_1_Y/A2
+ VSS carry_flag_sg13g2_o21ai_1_A1_B1_sg13g2_nand2_1_Y_B_sg13g2_a21oi_1_Y_A2_sg13g2_a21oi_1_Y_B1_sg13g2_o21ai_1_B1/A2
+ sg13g2_nor2_1
Xscan_reg\[33\]_sg13g2_dfrbpq_1_Q VDD scan_reg\[33\]_sg13g2_dfrbpq_1_Q/D scan_reg\[33\]_sg13g2_inv_1_A/A
+ clkbuf_5_24__f_clk/X VSS rst_n sg13g2_dfrbpq_1
Xclkbuf_4_11_0_clk clkbuf_4_11_0_clk/X VSS clkbuf_0_clk/X VDD sg13g2_buf_4
Xoverflow_flag_sg13g2_dfrbpq_1_Q_D_sg13g2_inv_1_Y_A_sg13g2_o21ai_1_Y_B1_sg13g2_nand3_1_Y_A_sg13g2_nand2_1_Y_B_sg13g2_a21oi_1_Y_A2_sg13g2_o21ai_1_Y_B1_sg13g2_a22oi_1_B2_Y_sg13g2_nand4_1_C_B_sg13g2_a22oi_1_Y
+ overflow_flag_sg13g2_dfrbpq_1_Q_D_sg13g2_inv_1_Y_A_sg13g2_o21ai_1_Y_B1_sg13g2_nand3_1_Y_A_sg13g2_nand2_1_Y_B_sg13g2_a21oi_1_Y_A2_sg13g2_o21ai_1_Y_B1_sg13g2_a22oi_1_B2_Y_sg13g2_nand4_1_C/B
+ overflow_flag_sg13g2_dfrbpq_1_Q_D_sg13g2_inv_1_Y_A_sg13g2_o21ai_1_Y_B1_sg13g2_nand3_1_Y_A_sg13g2_and4_1_A_D_sg13g2_a221oi_1_Y/A2
+ VDD serial_opcode\[0\]_sg13g2_o21ai_1_A1/Y serial_a\[5\]_sg13g2_dfrbpq_1_Q/Q VSS
+ serial_a\[7\]_sg13g2_dfrbpq_1_Q/Q sg13g2_a22oi_1
Xoperand_b\[3\]_sg13g2_dfrbpq_1_Q_D_sg13g2_a21oi_1_Y VDD VSS ui_in[2] serial_b\[3\]_sg13g2_inv_1_A/Y
+ operand_b\[3\]_sg13g2_nor2_1_A/Y operand_b\[3\]_sg13g2_dfrbpq_1_Q/D sg13g2_a21oi_1
Xscan_reg\[10\]_sg13g2_nor2_1_A scan_reg\[10\]_sg13g2_inv_1_A/A VDD scan_reg\[10\]_sg13g2_nor2_1_A/Y
+ VSS scan_reg\[3\]_sg13g2_nor2_1_A/B sg13g2_nor2_1
Xscan_reg\[25\]_sg13g2_dfrbpq_1_Q_D_sg13g2_a21oi_1_Y VDD VSS scan_out_sg13g2_a22oi_1_A1/B1
+ scan_reg\[26\]_sg13g2_inv_1_A/Y scan_reg\[25\]_sg13g2_o21ai_1_A1/Y scan_reg\[25\]_sg13g2_dfrbpq_1_Q/D
+ sg13g2_a21oi_1
Xscan_out_sg13g2_dfrbpq_1_Q VDD scan_out_sg13g2_dfrbpq_1_Q/D scan_out_sg13g2_dfrbpq_1_Q/Q
+ clkbuf_5_7__f_clk/X VSS rst_n sg13g2_dfrbpq_1
Xoperand_b\[5\]_sg13g2_mux2_1_A0 serial_b\[5\]_sg13g2_nand2b_1_B/B operand_b\[5\]_sg13g2_mux2_1_A0/X
+ ui_in[2] VDD VSS operand_b\[5\]_sg13g2_inv_1_A/A sg13g2_mux2_1
Xfault_counter\[7\]_sg13g2_dfrbpq_1_Q_D_sg13g2_xnor2_1_Y_B_sg13g2_or2_1_X scan_reg\[48\]_sg13g2_dfrbpq_1_Q_D_sg13g2_a221oi_1_Y/A2
+ VSS fault_counter\[5\]_sg13g2_dfrbpq_1_Q_D_sg13g2_and2_1_X/A fault_counter\[7\]_sg13g2_dfrbpq_1_Q_D_sg13g2_xnor2_1_Y/B
+ VDD sg13g2_or2_1
Xscan_reg\[53\]_sg13g2_dfrbpq_1_Q VDD scan_reg\[53\]_sg13g2_dfrbpq_1_Q/D scan_reg\[53\]_sg13g2_nor2_1_A/A
+ clkbuf_5_15__f_clk/X VSS rst_n sg13g2_dfrbpq_1
Xscan_reg\[23\]_sg13g2_nor2_1_A scan_reg\[23\]_sg13g2_nor2_1_A/A VDD scan_reg\[23\]_sg13g2_nor2_1_A/Y
+ VSS scan_reg\[3\]_sg13g2_nor2_1_A/B sg13g2_nor2_1
Xscan_reg\[49\]_sg13g2_o21ai_1_A1 VSS VDD scan_reg\[49\]_sg13g2_o21ai_1_A1/Y scan_reg\[49\]_sg13g2_o21ai_1_A1/B1
+ scan_reg\[41\]_sg13g2_nor2_1_A/B scan_reg\[49\]_sg13g2_nor2_1_A/A sg13g2_o21ai_1
Xlfsr\[6\]_sg13g2_a22oi_1_A1_B1_sg13g2_nor2_1_Y bist_state\[1\]_sg13g2_inv_1_A/Y VDD
+ lfsr\[7\]_sg13g2_a22oi_1_A1/B1 VSS lfsr\[7\]_sg13g2_a22oi_1_A1/A2 sg13g2_nor2_1
Xuo_out_sg13g2_dfrbpq_1_Q_5_D_sg13g2_a21oi_1_Y_A2_sg13g2_o21ai_1_Y_B1_sg13g2_or2_1_X_B_sg13g2_nand2_1_Y_A_sg13g2_a221oi_1_Y_C1_sg13g2_nand4_1_Y_B_sg13g2_o21ai_1_Y_B1_sg13g2_a21o_1_X_A1_sg13g2_nand2_1_Y
+ uo_out_sg13g2_dfrbpq_1_Q_5_D_sg13g2_a21oi_1_Y_A2_sg13g2_o21ai_1_Y_B1_sg13g2_or2_1_X_B_sg13g2_nand2_1_Y_A_sg13g2_a221oi_1_Y_C1_sg13g2_nand4_1_Y_B_sg13g2_o21ai_1_Y_B1_sg13g2_a21o_1_X/A1
+ VDD serial_b\[5\]_sg13g2_nand2b_1_B/B VSS serial_a\[5\]_sg13g2_dfrbpq_1_Q/Q sg13g2_nand2_1
Xuo_out_sg13g2_dfrbpq_1_Q_5_D_sg13g2_a21oi_1_Y_A2_sg13g2_o21ai_1_Y_B1_sg13g2_or2_1_X_B_sg13g2_nand2_1_Y_A_sg13g2_a221oi_1_Y_B2_sg13g2_xor2_1_X_A_sg13g2_nand2_1_Y_A_sg13g2_nand3_1_B_A_sg13g2_nand2b_1_Y
+ VSS serial_b\[5\]_sg13g2_nand2b_1_B/B uo_out_sg13g2_dfrbpq_1_Q_5_D_sg13g2_a21oi_1_Y_A2_sg13g2_o21ai_1_Y_B1_sg13g2_or2_1_X_B_sg13g2_nand2_1_Y_A_sg13g2_a221oi_1_Y_B2_sg13g2_xor2_1_X_A_sg13g2_nand2_1_Y_A_sg13g2_nand3_1_B/A
+ serial_a\[5\]_sg13g2_dfrbpq_1_Q/Q VDD sg13g2_nand2b_1
Xscan_reg\[46\]_sg13g2_dfrbpq_1_Q_D_sg13g2_a221oi_1_Y scan_reg\[47\]_sg13g2_nor2_1_A/Y
+ scan_reg\[46\]_sg13g2_dfrbpq_1_Q/D scan_out_sg13g2_a22oi_1_A1/A2 scan_reg\[46\]_sg13g2_inv_1_A/Y
+ scan_reg\[46\]_sg13g2_dfrbpq_1_Q_D_sg13g2_a221oi_1_Y/A2 VDD ui_in[3] VSS sg13g2_a221oi_1
Xbist_pattern_count\[6\]_sg13g2_dfrbpq_1_Q_D_sg13g2_nor3_1_Y bist_pattern_count\[6\]_sg13g2_a21oi_1_B1/Y
+ bist_pattern_count\[6\]_sg13g2_dfrbpq_1_Q/D bist_pattern_count\[6\]_sg13g2_dfrbpq_1_Q_D_sg13g2_nor3_1_Y/B
+ bist_fault_sg13g2_dfrbpq_1_Q_D_sg13g2_nor3_1_Y/A VDD VSS sg13g2_nor3_1
Xscan_reg\[49\]_sg13g2_nor2_1_A scan_reg\[49\]_sg13g2_nor2_1_A/A VDD scan_reg\[49\]_sg13g2_nor2_1_A/Y
+ VSS scan_reg\[3\]_sg13g2_nor2_1_A/B sg13g2_nor2_1
Xuo_out_sg13g2_dfrbpq_1_Q_6_D_sg13g2_a21oi_1_Y_A2_sg13g2_a21o_1_X_A2_sg13g2_and2_1_X_B_sg13g2_a22oi_1_Y_B2_sg13g2_and2_1_X_B_sg13g2_o21ai_1_Y
+ VSS VDD uo_out_sg13g2_dfrbpq_1_Q_6_D_sg13g2_a21oi_1_Y_A2_sg13g2_a21o_1_X_A2_sg13g2_and2_1_X_B_sg13g2_a22oi_1_Y_B2_sg13g2_and2_1_X/B
+ uo_out_sg13g2_dfrbpq_1_Q_6_D_sg13g2_a21oi_1_Y_A2_sg13g2_a21o_1_X_A2_sg13g2_and2_1_X_B_sg13g2_a22oi_1_Y_B2_sg13g2_and2_1_X_B_sg13g2_o21ai_1_Y/B1
+ uo_out_sg13g2_dfrbpq_1_Q_6_D_sg13g2_a21oi_1_Y_A2_sg13g2_a21o_1_X_A2_sg13g2_and2_1_X_B_sg13g2_a22oi_1_Y_B2_sg13g2_and2_1_X_B_sg13g2_o21ai_1_Y/A2
+ carry_flag_sg13g2_o21ai_1_A1_B1_sg13g2_nand2_1_Y_A_sg13g2_nand3_1_Y_A_sg13g2_a21oi_1_B1_Y_sg13g2_a221oi_1_B2_C1_sg13g2_o21ai_1_Y/A1
+ sg13g2_o21ai_1
Xuo_out_sg13g2_dfrbpq_1_Q_3_D_sg13g2_o21ai_1_Y_B1_sg13g2_nand2_1_Y_B_sg13g2_a22oi_1_Y
+ uo_out_sg13g2_dfrbpq_1_Q_3_D_sg13g2_o21ai_1_Y_B1_sg13g2_nand2_1_Y/B uo_out_sg13g2_dfrbpq_1_Q_3_D_sg13g2_o21ai_1_Y_B1_sg13g2_nand2_1_Y_B_sg13g2_a22oi_1_Y/A2
+ VDD uo_out_sg13g2_dfrbpq_1_Q_3_D_sg13g2_o21ai_1_Y_B1_sg13g2_nand2_1_Y_B_sg13g2_a22oi_1_Y/B1
+ uo_out_sg13g2_dfrbpq_1_Q_3_D_sg13g2_o21ai_1_Y_B1_sg13g2_nand2_1_Y_B_sg13g2_a22oi_1_Y/A1
+ VSS uo_out_sg13g2_dfrbpq_1_Q_3_D_sg13g2_o21ai_1_Y_B1_sg13g2_nand2_1_Y_B_sg13g2_a22oi_1_Y/B2
+ sg13g2_a22oi_1
Xclkbuf_5_23__f_clk clkbuf_5_23__f_clk/X VSS clkbuf_4_11_0_clk/X VDD sg13g2_buf_4
Xscan_reg\[5\]_sg13g2_dfrbpq_1_Q VDD scan_reg\[5\]_sg13g2_dfrbpq_1_Q/D scan_reg\[5\]_sg13g2_inv_1_A/A
+ clkbuf_5_23__f_clk/X VSS rst_n sg13g2_dfrbpq_1
Xcycle_counter\[7\]_sg13g2_dfrbpq_1_Q_D_sg13g2_xnor2_1_Y cycle_counter\[7\]_sg13g2_dfrbpq_1_Q/D
+ cycle_counter\[7\]_sg13g2_dfrbpq_1_Q_D_sg13g2_xnor2_1_Y/B VDD cycle_counter\[7\]_sg13g2_dfrbpq_1_Q/Q
+ VSS sg13g2_xnor2_1
Xfault_counter\[7\]_sg13g2_dfrbpq_1_Q VDD fault_counter\[7\]_sg13g2_dfrbpq_1_Q/D fault_counter\[7\]_sg13g2_dfrbpq_1_Q/Q
+ clkbuf_5_14__f_clk/X VSS rst_n sg13g2_dfrbpq_1
Xbist_a\[7\]_sg13g2_dfrbpq_1_Q_D_sg13g2_o21ai_1_Y_A1_sg13g2_o21ai_1_A1_Y_sg13g2_nand2b_1_A_N_B_sg13g2_a21oi_1_Y_B1_sg13g2_a21oi_1_Y
+ VDD VSS bist_a\[7\]_sg13g2_dfrbpq_1_Q_D_sg13g2_o21ai_1_Y_A1_sg13g2_o21ai_1_A1_Y_sg13g2_nand2b_1_A_N_B_sg13g2_a21oi_1_Y_B1_sg13g2_a21oi_1_Y/A2
+ bist_a\[7\]_sg13g2_dfrbpq_1_Q_D_sg13g2_o21ai_1_Y_A1_sg13g2_nand2_1_A_B_sg13g2_inv_1_Y_A_sg13g2_nor2_1_Y/B
+ bist_a\[1\]_sg13g2_dfrbpq_1_Q_D_sg13g2_o21ai_1_Y/A1 bist_a\[7\]_sg13g2_dfrbpq_1_Q_D_sg13g2_o21ai_1_Y_A1_sg13g2_o21ai_1_A1_Y_sg13g2_nand2b_1_A_N_B_sg13g2_a21oi_1_Y/B1
+ sg13g2_a21oi_1
Xoverflow_flag_sg13g2_dfrbpq_1_Q_D_sg13g2_inv_1_Y_A_sg13g2_o21ai_1_Y_B1_sg13g2_nand3_1_Y_A_sg13g2_and4_1_A_C_sg13g2_o21ai_1_Y_A2_sg13g2_and2_1_X
+ overflow_flag_sg13g2_dfrbpq_1_Q_D_sg13g2_inv_1_Y_A_sg13g2_o21ai_1_Y_B1_sg13g2_nand3_1_Y_A_sg13g2_and4_1_A_C_sg13g2_o21ai_1_Y/A2
+ VSS VDD serial_opcode\[2\]_sg13g2_nor2_1_A/Y serial_opcode\[1\]_sg13g2_nor2b_1_B_N/Y
+ sg13g2_and2_1
Xoperation\[2\]_sg13g2_inv_1_A operation\[2\]_sg13g2_inv_1_A/Y operation\[2\]_sg13g2_inv_1_A/A
+ VSS VDD sg13g2_inv_1
Xuo_out_sg13g2_dfrbpq_1_Q_D_sg13g2_a21oi_1_Y_B1_sg13g2_a21oi_1_Y_A1_sg13g2_nand3_1_Y_B_sg13g2_a221oi_1_Y_B1_sg13g2_xnor2_1_Y_A_sg13g2_a21oi_1_Y_A2_sg13g2_o21ai_1_Y_A2_sg13g2_xor2_1_B_X_sg13g2_nand3b_1_B
+ carry_flag_sg13g2_o21ai_1_A1_B1_sg13g2_nand2_1_Y_A_sg13g2_nand3_1_Y_B_sg13g2_nand3_1_Y_A_sg13g2_nor3_1_A/Y
+ overflow_flag_sg13g2_dfrbpq_1_Q_D_sg13g2_inv_1_Y_A_sg13g2_o21ai_1_Y_B1_sg13g2_nand3_1_Y_A_sg13g2_nand2_1_Y_B_sg13g2_a21oi_1_Y_A2_sg13g2_nand3_1_C_Y_sg13g2_nand3_1_B_Y_sg13g2_nand4_1_B/D
+ VDD VSS uo_out_sg13g2_dfrbpq_1_Q_D_sg13g2_a21oi_1_Y_B1_sg13g2_a21oi_1_Y_A1_sg13g2_nand3_1_Y_B_sg13g2_a221oi_1_Y_B1_sg13g2_xnor2_1_Y_A_sg13g2_a21oi_1_Y_A2_sg13g2_o21ai_1_Y_A2_sg13g2_xor2_1_B/X
+ carry_flag_sg13g2_o21ai_1_A1_B1_sg13g2_nand2_1_Y_A_sg13g2_nand3_1_Y_A_sg13g2_a21oi_1_B1_Y_sg13g2_a22oi_1_B2/B1
+ sg13g2_nand3b_1
Xmisr\[1\]_sg13g2_a22oi_1_B2_A2_sg13g2_nor2_1_Y uio_in[6] VDD misr\[1\]_sg13g2_a22oi_1_B2/A2
+ VSS uio_in[7] sg13g2_nor2_1
Xserial_a\[7\]_sg13g2_dfrbpq_1_Q VDD serial_a\[7\]_sg13g2_dfrbpq_1_Q/D serial_a\[7\]_sg13g2_dfrbpq_1_Q/Q
+ clkbuf_5_21__f_clk/X VSS rst_n sg13g2_dfrbpq_1
Xoverflow_flag_sg13g2_dfrbpq_1_Q_D_sg13g2_inv_1_Y_A_sg13g2_o21ai_1_Y VSS VDD overflow_flag_sg13g2_dfrbpq_1_Q_D_sg13g2_inv_1_Y/A
+ overflow_flag_sg13g2_dfrbpq_1_Q_D_sg13g2_inv_1_Y_A_sg13g2_o21ai_1_Y/B1 ui_in[2]
+ overflow_flag_sg13g2_dfrbpq_1_Q/Q sg13g2_o21ai_1
Xserial_opcode\[3\]_sg13g2_dfrbpq_1_Q_D_sg13g2_o21ai_1_Y_B1_sg13g2_nand2_1_Y serial_opcode\[3\]_sg13g2_dfrbpq_1_Q_D_sg13g2_o21ai_1_Y/B1
+ VDD ui_in[1] VSS ui_in[0] sg13g2_nand2_1
Xbist_a\[7\]_sg13g2_dfrbpq_1_Q_D_sg13g2_o21ai_1_Y_A1_sg13g2_nand2_1_A_Y_sg13g2_a221oi_1_A1_Y_sg13g2_o21ai_1_B1_A2_sg13g2_nand2_1_Y
+ bist_a\[7\]_sg13g2_dfrbpq_1_Q_D_sg13g2_o21ai_1_Y_A1_sg13g2_nand2_1_A_Y_sg13g2_a221oi_1_A1_Y_sg13g2_o21ai_1_B1/A2
+ VDD bist_a\[0\]_sg13g2_dfrbpq_1_Q/Q VSS bist_a\[7\]_sg13g2_dfrbpq_1_Q_D_sg13g2_o21ai_1_Y_A1_sg13g2_o21ai_1_A1_Y_sg13g2_nand2b_1_A_N_B_sg13g2_a21oi_1_Y/A2
+ sg13g2_nand2_1
Xuo_out_sg13g2_dfrbpq_1_Q_6_D_sg13g2_a21oi_1_Y_A2_sg13g2_a21o_1_X_A2_sg13g2_and2_1_X_A_sg13g2_a221oi_1_Y_C1_sg13g2_nand3_1_Y
+ VDD uo_out_sg13g2_dfrbpq_1_Q_6_D_sg13g2_a21oi_1_Y_A2_sg13g2_a21o_1_X_A2_sg13g2_and2_1_X_A_sg13g2_a221oi_1_Y/C1
+ uo_out_sg13g2_dfrbpq_1_Q_6_D_sg13g2_a21oi_1_Y_A2_sg13g2_a21o_1_X_A2_sg13g2_and2_1_X_A_sg13g2_a221oi_1_Y_C1_sg13g2_nand3_1_Y/B
+ uo_out_sg13g2_dfrbpq_1_Q_6_D_sg13g2_a21oi_1_Y_A2_sg13g2_a21o_1_X_A2_sg13g2_and2_1_X_A_sg13g2_a221oi_1_Y_C1_sg13g2_nand3_1_Y/C
+ carry_flag_sg13g2_o21ai_1_A1_B1_sg13g2_nand2_1_Y_A_sg13g2_nand3_1_Y_A_sg13g2_a21oi_1_B1_Y_sg13g2_a22oi_1_B2/Y
+ VSS sg13g2_nand3_1
Xuo_out_sg13g2_dfrbpq_1_Q_6_D_sg13g2_a21oi_1_Y_A2_sg13g2_a21o_1_X_A2_sg13g2_and2_1_X_A_sg13g2_a221oi_1_Y_C1_sg13g2_nand3_1_Y_C_sg13g2_a221oi_1_Y_C1_sg13g2_o21ai_1_Y_B1_sg13g2_o21ai_1_Y
+ VSS VDD uo_out_sg13g2_dfrbpq_1_Q_6_D_sg13g2_a21oi_1_Y_A2_sg13g2_a21o_1_X_A2_sg13g2_and2_1_X_A_sg13g2_a221oi_1_Y_C1_sg13g2_nand3_1_Y_C_sg13g2_a221oi_1_Y_C1_sg13g2_o21ai_1_Y/B1
+ serial_opcode\[2\]_sg13g2_nor3_1_A/Y serial_b\[4\]_sg13g2_nand2_1_A/B serial_b\[4\]_sg13g2_nand2_1_A/A
+ sg13g2_o21ai_1
Xbist_a\[6\]_sg13g2_dfrbpq_1_Q VDD lfsr\[6\]_sg13g2_mux2_1_A1/X lfsr\[6\]_sg13g2_mux2_1_A1/A0
+ clkload0/A VSS rst_n sg13g2_dfrbpq_1
Xclkbuf_5_4__f_clk clkbuf_5_4__f_clk/X VSS clkbuf_4_2_0_clk/X VDD sg13g2_buf_4
Xscan_reg\[56\]_sg13g2_dfrbpq_1_Q_D_sg13g2_a21oi_1_Y VDD VSS scan_reg\[57\]_sg13g2_nor2_1_A/Y
+ ui_in[6] scan_reg\[56\]_sg13g2_o21ai_1_A1/Y scan_reg\[56\]_sg13g2_dfrbpq_1_Q/D sg13g2_a21oi_1
Xmisr\[6\]_sg13g2_dfrbpq_1_Q_D_sg13g2_o21ai_1_Y_A2_sg13g2_xnor2_1_Y misr\[6\]_sg13g2_dfrbpq_1_Q_D_sg13g2_o21ai_1_Y/A2
+ misr\[6\]_sg13g2_dfrbpq_1_Q_D_sg13g2_o21ai_1_Y_A2_sg13g2_xnor2_1_Y/B VDD misr\[5\]_sg13g2_dfrbpq_1_Q/Q
+ VSS sg13g2_xnor2_1
Xbist_a\[7\]_sg13g2_dfrbpq_1_Q_D_sg13g2_o21ai_1_Y_A1_sg13g2_nand2_1_A_Y_sg13g2_a221oi_1_A1_Y_sg13g2_o21ai_1_B1_A1_sg13g2_xnor2_1_Y
+ bist_a\[7\]_sg13g2_dfrbpq_1_Q_D_sg13g2_o21ai_1_Y_A1_sg13g2_nand2_1_A_Y_sg13g2_a221oi_1_A1_Y_sg13g2_o21ai_1_B1/A1
+ bist_a\[7\]_sg13g2_dfrbpq_1_Q_D_sg13g2_o21ai_1_Y_A1_sg13g2_nand2_1_A_Y_sg13g2_a221oi_1_A1_Y_sg13g2_o21ai_1_B1_A1_sg13g2_xnor2_1_Y/B
+ VDD bist_a\[7\]_sg13g2_dfrbpq_1_Q_D_sg13g2_o21ai_1_Y_A1_sg13g2_nand2_1_A_Y_sg13g2_a221oi_1_B2_Y_sg13g2_o21ai_1_B1_A1_sg13g2_nor3_1_Y/A
+ VSS sg13g2_xnor2_1
Xuo_out_sg13g2_dfrbpq_1_Q_6_D_sg13g2_a21oi_1_Y_A2_sg13g2_a21o_1_X_A2_sg13g2_and2_1_X_B_sg13g2_a22oi_1_Y_B2_sg13g2_and2_1_X_B_sg13g2_o21ai_1_Y_B1_sg13g2_xnor2_1_Y
+ uo_out_sg13g2_dfrbpq_1_Q_6_D_sg13g2_a21oi_1_Y_A2_sg13g2_a21o_1_X_A2_sg13g2_and2_1_X_B_sg13g2_a22oi_1_Y_B2_sg13g2_and2_1_X_B_sg13g2_o21ai_1_Y/B1
+ serial_b\[4\]_sg13g2_nand2_1_A/B VDD serial_b\[4\]_sg13g2_nand2_1_A/A VSS sg13g2_xnor2_1
Xserial_opcode\[2\]_sg13g2_nor2_1_A serial_opcode\[2\]_sg13g2_inv_1_A/A VDD serial_opcode\[2\]_sg13g2_nor2_1_A/Y
+ VSS serial_opcode\[3\]_sg13g2_nor2_1_B/B sg13g2_nor2_1
Xbist_a\[7\]_sg13g2_dfrbpq_1_Q_D_sg13g2_o21ai_1_Y_A1_sg13g2_o21ai_1_A1 VSS VDD bist_a\[7\]_sg13g2_dfrbpq_1_Q_D_sg13g2_o21ai_1_Y_A1_sg13g2_o21ai_1_A1/Y
+ bist_a\[7\]_sg13g2_dfrbpq_1_Q_D_sg13g2_o21ai_1_Y_A1_sg13g2_o21ai_1_A1/B1 bist_a\[7\]_sg13g2_dfrbpq_1_Q_D_sg13g2_o21ai_1_Y_A1_sg13g2_o21ai_1_A1/A2
+ bist_a\[7\]_sg13g2_dfrbpq_1_Q_D_sg13g2_o21ai_1_Y/A1 sg13g2_o21ai_1
Xclkbuf_4_10_0_clk clkbuf_4_10_0_clk/X VSS clkbuf_0_clk/X VDD sg13g2_buf_4
Xbist_pattern_count\[1\]_sg13g2_dfrbpq_1_Q_D_sg13g2_nor3_1_Y bist_pattern_count\[1\]_sg13g2_and3_1_A/X
+ bist_pattern_count\[1\]_sg13g2_dfrbpq_1_Q/D bist_fault_sg13g2_dfrbpq_1_Q_D_sg13g2_nor3_1_Y/A
+ bist_pattern_count\[1\]_sg13g2_dfrbpq_1_Q_D_sg13g2_nor3_1_Y/C VDD VSS sg13g2_nor3_1
Xscan_reg\[26\]_sg13g2_dfrbpq_1_Q VDD scan_reg\[26\]_sg13g2_dfrbpq_1_Q/D scan_reg\[26\]_sg13g2_inv_1_A/A
+ clkbuf_5_30__f_clk/X VSS rst_n sg13g2_dfrbpq_1
Xserial_b\[5\]_sg13g2_dfrbpq_1_Q_D_sg13g2_mux2_1_X serial_b\[6\]_sg13g2_and2_1_A/A
+ serial_b\[5\]_sg13g2_dfrbpq_1_Q/D ui_in[1] VDD VSS serial_b\[5\]_sg13g2_nand2b_1_B/B
+ sg13g2_mux2_1
Xbist_a\[7\]_sg13g2_dfrbpq_1_Q_D_sg13g2_o21ai_1_Y_A1_sg13g2_nand2_1_A_B_sg13g2_o21ai_1_A2_B1_sg13g2_nand3_1_C
+ VDD bist_a\[7\]_sg13g2_dfrbpq_1_Q_D_sg13g2_o21ai_1_Y_A1_sg13g2_nand2_1_A_B_sg13g2_o21ai_1_A2_B1_sg13g2_nand3_1_C/Y
+ bist_a\[7\]_sg13g2_dfrbpq_1_Q_D_sg13g2_o21ai_1_Y_A1_sg13g2_o21ai_1_A1/A2 bist_a\[7\]_sg13g2_dfrbpq_1_Q_D_sg13g2_o21ai_1_Y_A1_sg13g2_nand2_1_A_B_sg13g2_o21ai_1_A2/B1
+ bist_a\[7\]_sg13g2_dfrbpq_1_Q_D_sg13g2_o21ai_1_Y_A1_sg13g2_nand2_1_A_B_sg13g2_inv_1_Y_A_sg13g2_nor2_1_Y/B
+ VSS sg13g2_nand3_1
Xlfsr\[5\]_sg13g2_dfrbpq_1_Q_D_sg13g2_inv_1_Y lfsr\[5\]_sg13g2_dfrbpq_1_Q/D lfsr\[5\]_sg13g2_dfrbpq_1_Q_D_sg13g2_inv_1_Y/A
+ VSS VDD sg13g2_inv_1
Xscan_reg\[46\]_sg13g2_dfrbpq_1_Q VDD scan_reg\[46\]_sg13g2_dfrbpq_1_Q/D scan_reg\[46\]_sg13g2_inv_1_A/A
+ clkbuf_5_10__f_clk/X VSS rst_n sg13g2_dfrbpq_1
Xscan_reg\[54\]_sg13g2_dfrbpq_1_Q_D_sg13g2_a221oi_1_Y_A1_sg13g2_inv_1_Y scan_reg\[54\]_sg13g2_dfrbpq_1_Q_D_sg13g2_a221oi_1_Y/A1
+ bist_done_sg13g2_a22oi_1_B2/A1 VSS VDD sg13g2_inv_1
Xscan_reg\[40\]_sg13g2_a21o_1_A1 scan_reg\[40\]_sg13g2_a21o_1_A1/B1 scan_reg\[40\]_sg13g2_a21o_1_A1/X
+ VDD VSS scan_reg\[40\]_sg13g2_dfrbpq_1_Q/Q scan_out_sg13g2_a22oi_1_A1/A2 sg13g2_a21o_1
Xbist_a\[7\]_sg13g2_dfrbpq_1_Q_D_sg13g2_o21ai_1_Y_A1_sg13g2_o21ai_1_A1_B1_sg13g2_nand4_1_C_Y_sg13g2_a221oi_1_C1_B1_sg13g2_nor2_1_Y_B_sg13g2_a21oi_1_Y
+ VDD VSS bist_a\[7\]_sg13g2_dfrbpq_1_Q_D_sg13g2_o21ai_1_Y_A1_sg13g2_o21ai_1_A1_B1_sg13g2_nand4_1_C_Y_sg13g2_a221oi_1_C1_B1_sg13g2_nor2_1_Y_A_sg13g2_and3_1_X/C
+ bist_a\[7\]_sg13g2_or2_1_A/X bist_a\[4\]_sg13g2_dfrbpq_1_Q/Q bist_a\[7\]_sg13g2_dfrbpq_1_Q_D_sg13g2_o21ai_1_Y_A1_sg13g2_o21ai_1_A1_B1_sg13g2_nand4_1_C_Y_sg13g2_a221oi_1_C1_B1_sg13g2_nor2_1_Y/B
+ sg13g2_a21oi_1
Xbist_a\[7\]_sg13g2_dfrbpq_1_Q_D_sg13g2_o21ai_1_Y_A1_sg13g2_o21ai_1_A1_Y_sg13g2_nand2b_1_A_N_B_sg13g2_a21oi_1_Y_A2_sg13g2_a21oi_1_Y
+ VDD VSS misr\[4\]_sg13g2_inv_1_A_Y_sg13g2_xnor2_1_A_B_sg13g2_o21ai_1_Y_A1_sg13g2_a21oi_1_Y_A2_sg13g2_a21oi_1_Y_A1_sg13g2_nor2b_1_Y/A
+ bist_a\[1\]_sg13g2_dfrbpq_1_Q/Q bist_a\[7\]_sg13g2_dfrbpq_1_Q_D_sg13g2_o21ai_1_Y_A1_sg13g2_o21ai_1_A1_Y_sg13g2_nand2b_1_A_N_B_sg13g2_a21oi_1_Y_A2_sg13g2_a21oi_1_Y/B1
+ bist_a\[7\]_sg13g2_dfrbpq_1_Q_D_sg13g2_o21ai_1_Y_A1_sg13g2_o21ai_1_A1_Y_sg13g2_nand2b_1_A_N_B_sg13g2_a21oi_1_Y/A2
+ sg13g2_a21oi_1
Xuo_out_sg13g2_dfrbpq_1_Q_2_D_sg13g2_o21ai_1_Y_B1_sg13g2_nand3_1_Y_B_sg13g2_nand2_1_Y_B_sg13g2_nand2_1_Y
+ uo_out_sg13g2_dfrbpq_1_Q_2_D_sg13g2_o21ai_1_Y_B1_sg13g2_nand3_1_Y_B_sg13g2_nand2_1_Y/B
+ VDD uio_in[0] VSS uo_out_sg13g2_dfrbpq_1_Q_2_D_sg13g2_o21ai_1_Y_B1_sg13g2_nand3_1_Y_C_sg13g2_nand3_1_Y_B_sg13g2_or2_1_X/B
+ sg13g2_nand2_1
Xbist_a\[7\]_sg13g2_dfrbpq_1_Q_D_sg13g2_o21ai_1_Y_A1_sg13g2_nand2_1_A_Y_sg13g2_a221oi_1_B2_A2_sg13g2_xnor2_1_Y
+ bist_a\[7\]_sg13g2_dfrbpq_1_Q_D_sg13g2_o21ai_1_Y_A1_sg13g2_nand2_1_A_Y_sg13g2_a221oi_1_B2/A2
+ bist_a\[7\]_sg13g2_dfrbpq_1_Q_D_sg13g2_o21ai_1_Y_A1_sg13g2_nand2_1_A_Y_sg13g2_a221oi_1_B2_A2_sg13g2_xnor2_1_Y/B
+ VDD bist_a\[7\]_sg13g2_dfrbpq_1_Q_D_sg13g2_o21ai_1_Y_A1_sg13g2_nand2_1_A_Y_sg13g2_a221oi_1_B2_A2_sg13g2_xnor2_1_Y/A
+ VSS sg13g2_xnor2_1
Xbist_done_sg13g2_a22oi_1_B2 uio_out_sg13g2_nand2_1_Y_7/A bist_done_sg13g2_a22oi_1_B2/A2
+ VDD misr\[1\]_sg13g2_a22oi_1_B2/A2 bist_done_sg13g2_a22oi_1_B2/A1 VSS bist_done_sg13g2_inv_1_A/A
+ sg13g2_a22oi_1
Xserial_b\[1\]_sg13g2_dfrbpq_1_Q_D_sg13g2_o21ai_1_Y_B1_sg13g2_nand2_1_Y serial_b\[1\]_sg13g2_dfrbpq_1_Q_D_sg13g2_o21ai_1_Y/B1
+ VDD serial_b\[2\]_sg13g2_xor2_1_A/A VSS ui_in[1] sg13g2_nand2_1
Xmisr\[7\]_sg13g2_dfrbpq_1_Q_D_sg13g2_a22oi_1_Y_B2_sg13g2_o21ai_1_Y_A2_sg13g2_a22oi_1_Y_B2_sg13g2_a21oi_1_Y
+ VDD VSS misr\[7\]_sg13g2_dfrbpq_1_Q_D_sg13g2_a22oi_1_Y_B2_sg13g2_o21ai_1_Y_A2_sg13g2_a22oi_1_Y_B2_sg13g2_a21oi_1_Y/A2
+ uio_in[1] negative_flag_sg13g2_dfrbpq_1_Q_D_sg13g2_a21oi_1_Y_A2_sg13g2_o21ai_1_Y/A1
+ misr\[7\]_sg13g2_dfrbpq_1_Q_D_sg13g2_a22oi_1_Y_B2_sg13g2_o21ai_1_Y_A2_sg13g2_a22oi_1_Y/B2
+ sg13g2_a21oi_1
Xserial_a\[3\]_sg13g2_dfrbpq_1_Q_D_sg13g2_mux2_1_X serial_b\[4\]_sg13g2_nand2_1_A/B
+ serial_a\[3\]_sg13g2_dfrbpq_1_Q/D ui_in[1] VDD VSS serial_a\[3\]_sg13g2_dfrbpq_1_Q/Q
+ sg13g2_mux2_1
Xbist_pattern_count\[5\]_sg13g2_dfrbpq_1_Q VDD bist_pattern_count\[5\]_sg13g2_dfrbpq_1_Q/D
+ bist_pattern_count\[6\]_sg13g2_nand3_1_C/B clkbuf_5_2__f_clk/X VSS rst_n sg13g2_dfrbpq_1
Xbist_a\[7\]_sg13g2_dfrbpq_1_Q_D_sg13g2_o21ai_1_Y_A1_sg13g2_o21ai_1_A1_B1_sg13g2_a21oi_1_Y
+ VDD VSS bist_a\[7\]_sg13g2_dfrbpq_1_Q_D_sg13g2_o21ai_1_Y_A1_sg13g2_o21ai_1_A1_B1_sg13g2_a21oi_1_Y/A2
+ bist_a\[4\]_sg13g2_dfrbpq_1_Q/Q bist_a\[7\]_sg13g2_dfrbpq_1_Q_D_sg13g2_o21ai_1_Y_A1_sg13g2_o21ai_1_A1_B1_sg13g2_a21oi_1_Y/B1
+ bist_a\[7\]_sg13g2_dfrbpq_1_Q_D_sg13g2_o21ai_1_Y_A1_sg13g2_o21ai_1_A1/B1 sg13g2_a21oi_1
Xfault_counter\[4\]_sg13g2_dfrbpq_1_Q_D_sg13g2_xnor2_1_Y fault_counter\[4\]_sg13g2_dfrbpq_1_Q/D
+ fault_counter\[3\]_sg13g2_dfrbpq_1_Q_D_sg13g2_nor2_1_Y/A VDD scan_reg\[46\]_sg13g2_dfrbpq_1_Q_D_sg13g2_a221oi_1_Y/A2
+ VSS sg13g2_xnor2_1
Xoverflow_flag_sg13g2_dfrbpq_1_Q_D_sg13g2_inv_1_Y_A_sg13g2_o21ai_1_Y_B1_sg13g2_nand3_1_Y_A_sg13g2_nand2_1_Y_B_sg13g2_a21oi_1_Y_A2_sg13g2_nand3_1_C_Y_sg13g2_nand3_1_B
+ VDD overflow_flag_sg13g2_dfrbpq_1_Q_D_sg13g2_inv_1_Y_A_sg13g2_o21ai_1_Y_B1_sg13g2_nand3_1_Y_A_sg13g2_nand2_1_Y_B_sg13g2_a21oi_1_Y_A2_sg13g2_nand3_1_C_Y_sg13g2_nand3_1_B/Y
+ uo_out_sg13g2_dfrbpq_1_Q_D_sg13g2_a21oi_1_Y_B1_sg13g2_a21oi_1_Y_A1_sg13g2_nand3_1_Y_B_sg13g2_a221oi_1_Y_C1_sg13g2_o21ai_1_Y_A1_sg13g2_a21oi_1_Y/A2
+ overflow_flag_sg13g2_dfrbpq_1_Q_D_sg13g2_inv_1_Y_A_sg13g2_o21ai_1_Y_B1_sg13g2_nand3_1_Y_A_sg13g2_nand2_1_Y_B_sg13g2_a21oi_1_Y_A2_sg13g2_nand3_1_C_Y_sg13g2_nand3_1_B/C
+ carry_flag_sg13g2_o21ai_1_A1_B1_sg13g2_nand2_1_Y_A_sg13g2_nand3_1_Y_A_sg13g2_a21oi_1_B1_Y_sg13g2_a22oi_1_B2/A1
+ VSS sg13g2_nand3_1
Xmisr\[4\]_sg13g2_inv_1_A_Y_sg13g2_xnor2_1_A_B_sg13g2_o21ai_1_Y_B1_sg13g2_or2_1_X_B_sg13g2_nor2_1_Y
+ uo_out_sg13g2_dfrbpq_1_Q_6_D_sg13g2_a21oi_1_Y_A2_sg13g2_a21o_1_X_A1_sg13g2_or3_1_X/C
+ VDD misr\[4\]_sg13g2_inv_1_A_Y_sg13g2_xnor2_1_A_B_sg13g2_o21ai_1_Y_B1_sg13g2_or2_1_X/B
+ VSS misr\[4\]_sg13g2_inv_1_A_Y_sg13g2_xnor2_1_A_B_sg13g2_o21ai_1_Y_B1_sg13g2_or2_1_X_B_sg13g2_nor2_1_Y/B
+ sg13g2_nor2_1
Xoperation\[0\]_sg13g2_mux2_1_A0 operation\[0\]_sg13g2_mux2_1_A0/A1 operation\[0\]_sg13g2_mux2_1_A0/X
+ ui_in[2] VDD VSS operation\[0\]_sg13g2_mux2_1_A0/A0 sg13g2_mux2_1
Xoperand_a\[6\]_sg13g2_mux2_1_A0 serial_b\[6\]_sg13g2_and2_1_A/B operand_a\[6\]_sg13g2_mux2_1_A0/X
+ ui_in[2] VDD VSS operand_a\[6\]_sg13g2_mux2_1_A0/A0 sg13g2_mux2_1
Xscan_reg\[54\]_sg13g2_inv_1_A scan_reg\[54\]_sg13g2_inv_1_A/Y scan_reg\[54\]_sg13g2_inv_1_A/A
+ VSS VDD sg13g2_inv_1
Xoperand_b\[0\]_sg13g2_dfrbpq_1_Q VDD operand_b\[0\]_sg13g2_mux2_1_A0/X operand_b\[0\]_sg13g2_mux2_1_A0/A0
+ clkbuf_5_19__f_clk/X VSS rst_n sg13g2_dfrbpq_1
Xscan_reg\[3\]_sg13g2_nor2_1_A scan_reg\[3\]_sg13g2_nor2_1_A/A VDD scan_reg\[3\]_sg13g2_nor2_1_A/Y
+ VSS scan_reg\[3\]_sg13g2_nor2_1_A/B sg13g2_nor2_1
Xuo_out_sg13g2_dfrbpq_1_Q_6_D_sg13g2_a21oi_1_Y_A2_sg13g2_a21o_1_X_B1_sg13g2_a221oi_1_Y_C1_sg13g2_nand2b_1_Y
+ VSS uo_out_sg13g2_dfrbpq_1_Q_6_D_sg13g2_a21oi_1_Y_A2_sg13g2_a21o_1_X/A1 uo_out_sg13g2_dfrbpq_1_Q_6_D_sg13g2_a21oi_1_Y_A2_sg13g2_a21o_1_X_B1_sg13g2_a221oi_1_Y/C1
+ misr\[1\]_sg13g2_inv_1_A_Y_sg13g2_xnor2_1_A_B_sg13g2_o21ai_1_Y_B1_sg13g2_nand4_1_Y/A
+ VDD sg13g2_nand2b_1
Xuo_out_sg13g2_dfrbpq_1_Q_D_sg13g2_a21oi_1_Y_A1_sg13g2_inv_1_Y uo_out_sg13g2_dfrbpq_1_Q_D_sg13g2_a21oi_1_Y/A1
+ uo_out[3] VSS VDD sg13g2_inv_1
Xmisr\[7\]_sg13g2_dfrbpq_1_Q VDD misr\[7\]_sg13g2_dfrbpq_1_Q/D misr\[7\]_sg13g2_dfrbpq_1_Q/Q
+ clkbuf_5_13__f_clk/X VSS rst_n sg13g2_dfrbpq_1
Xserial_opcode\[3\]_sg13g2_dfrbpq_1_Q VDD serial_opcode\[3\]_sg13g2_dfrbpq_1_Q/D serial_opcode\[3\]_sg13g2_nor2_1_B/B
+ clkbuf_5_28__f_clk/X VSS rst_n sg13g2_dfrbpq_1
Xmisr\[0\]_sg13g2_dfrbpq_1_Q_D_sg13g2_a22oi_1_Y_B2_sg13g2_o21ai_1_Y_A2_sg13g2_a21oi_1_Y_A2_sg13g2_nor2b_1_Y
+ misr\[0\]_sg13g2_dfrbpq_1_Q_D_sg13g2_a22oi_1_Y_B2_sg13g2_o21ai_1_Y_A2_sg13g2_a21oi_1_Y_A2_sg13g2_nor2b_1_Y/A
+ misr\[0\]_sg13g2_dfrbpq_1_Q_D_sg13g2_a22oi_1_Y_B2_sg13g2_o21ai_1_Y_A2_sg13g2_a21oi_1_Y_A2_sg13g2_nor2b_1_Y/B_N
+ VDD misr\[0\]_sg13g2_dfrbpq_1_Q_D_sg13g2_a22oi_1_Y_B2_sg13g2_o21ai_1_Y_A2_sg13g2_a21oi_1_Y/A2
+ VSS sg13g2_nor2b_1
Xmisr\[4\]_sg13g2_a22oi_1_B2_B1_sg13g2_nor2b_1_Y uio_in[7] uio_in[6] VDD misr\[4\]_sg13g2_a22oi_1_B2/B1
+ VSS sg13g2_nor2b_1
Xscan_reg\[10\]_sg13g2_dfrbpq_1_Q_D_sg13g2_a21oi_1_Y VDD VSS scan_out_sg13g2_a22oi_1_A1/A2
+ scan_reg\[10\]_sg13g2_inv_1_A/Y scan_reg\[11\]_sg13g2_o21ai_1_A1/Y scan_reg\[10\]_sg13g2_dfrbpq_1_Q/D
+ sg13g2_a21oi_1
Xoverflow_flag_sg13g2_dfrbpq_1_Q_D_sg13g2_inv_1_Y_A_sg13g2_o21ai_1_Y_B1_sg13g2_nand3_1_Y_A_sg13g2_and4_1_A_D_sg13g2_a221oi_1_Y_B1_sg13g2_nand3_1_Y_B_sg13g2_inv_1_Y
+ overflow_flag_sg13g2_dfrbpq_1_Q_D_sg13g2_inv_1_Y_A_sg13g2_o21ai_1_Y_B1_sg13g2_nand3_1_Y_A_sg13g2_and4_1_A_D_sg13g2_a221oi_1_Y_B1_sg13g2_nand3_1_Y/B
+ serial_opcode\[2\]_sg13g2_nor3_1_A/Y VSS VDD sg13g2_inv_1
Xscan_reg\[11\]_sg13g2_o21ai_1_A1 VSS VDD scan_reg\[11\]_sg13g2_o21ai_1_A1/Y scan_reg\[11\]_sg13g2_o21ai_1_A1/B1
+ scan_reg\[3\]_sg13g2_nor2_1_A/B scan_reg\[11\]_sg13g2_dfrbpq_1_Q/Q sg13g2_o21ai_1
Xoverflow_flag_sg13g2_dfrbpq_1_Q_D_sg13g2_inv_1_Y_A_sg13g2_o21ai_1_Y_B1_sg13g2_nand3_1_Y_C_sg13g2_a21oi_1_Y_A1_sg13g2_o21ai_1_A2_B1_sg13g2_o21ai_1_A1
+ VSS VDD overflow_flag_sg13g2_dfrbpq_1_Q_D_sg13g2_inv_1_Y_A_sg13g2_o21ai_1_Y_B1_sg13g2_nand3_1_Y_C_sg13g2_a21oi_1_Y_A1_sg13g2_o21ai_1_A2_B1_sg13g2_o21ai_1_A1/Y
+ overflow_flag_sg13g2_dfrbpq_1_Q_D_sg13g2_inv_1_Y_A_sg13g2_o21ai_1_Y_B1_sg13g2_nand3_1_Y_C_sg13g2_a21oi_1_Y_A1_sg13g2_o21ai_1_A2_B1_sg13g2_o21ai_1_A1/B1
+ carry_flag_sg13g2_o21ai_1_A1_B1_sg13g2_nand2_1_Y_B_sg13g2_a21oi_1_Y_A2_sg13g2_a21oi_1_Y_B1_sg13g2_o21ai_1_B1_Y_sg13g2_a221oi_1_B1_1/B2
+ overflow_flag_sg13g2_dfrbpq_1_Q_D_sg13g2_inv_1_Y_A_sg13g2_o21ai_1_Y_B1_sg13g2_nand3_1_Y_C_sg13g2_a21oi_1_Y_A1_sg13g2_o21ai_1_A2/B1
+ sg13g2_o21ai_1
Xcycle_counter\[2\]_sg13g2_dfrbpq_1_Q_D_sg13g2_and2_1_X_A_sg13g2_nand3_1_Y VDD cycle_counter\[2\]_sg13g2_dfrbpq_1_Q_D_sg13g2_and2_1_X/A
+ cycle_counter\[1\]_sg13g2_dfrbpq_1_Q/Q cycle_counter\[2\]_sg13g2_dfrbpq_1_Q/Q cycle_counter\[0\]_sg13g2_dfrbpq_1_Q/Q
+ VSS sg13g2_nand3_1
Xcarry_flag_sg13g2_o21ai_1_A1_B1_sg13g2_nand2_1_Y_A_sg13g2_nand3_1_Y_B_sg13g2_nand3_1_C_Y_sg13g2_o21ai_1_B1_A2_sg13g2_nor3_1_Y_C_sg13g2_nor4_1_Y_D_sg13g2_nand2_1_Y
+ carry_flag_sg13g2_o21ai_1_A1_B1_sg13g2_nand2_1_Y_A_sg13g2_nand3_1_Y_B_sg13g2_nand3_1_C_Y_sg13g2_o21ai_1_B1_A2_sg13g2_nor3_1_Y_C_sg13g2_nor4_1_Y/D
+ VDD carry_flag_sg13g2_o21ai_1_A1_B1_sg13g2_nand2_1_Y_A_sg13g2_nand3_1_Y_B_sg13g2_nand3_1_C_Y_sg13g2_o21ai_1_B1_A2_sg13g2_nor3_1_Y_C_sg13g2_nor4_1_Y_D_sg13g2_nand2_1_Y/A
+ VSS uo_out_sg13g2_dfrbpq_1_Q_6_D_sg13g2_a21oi_1_Y_A2_sg13g2_a21o_1_X_A2_sg13g2_and2_1_X_B_sg13g2_a22oi_1_Y_B2_sg13g2_and2_1_X_B_sg13g2_o21ai_1_Y/B1
+ sg13g2_nand2_1
Xscan_reg\[0\]_sg13g2_inv_1_A scan_reg\[0\]_sg13g2_inv_1_A/Y scan_out_sg13g2_a22oi_1_A1/B2
+ VSS VDD sg13g2_inv_1
Xlfsr\[6\]_sg13g2_dfrbpq_1_Q VDD lfsr\[6\]_sg13g2_dfrbpq_1_Q/D lfsr\[6\]_sg13g2_mux2_1_A1/A1
+ clkbuf_5_0__f_clk/X VSS rst_n sg13g2_dfrbpq_1
Xmisr\[6\]_sg13g2_dfrbpq_1_Q_D_sg13g2_o21ai_1_Y_A2_sg13g2_xnor2_1_Y_B_sg13g2_a22oi_1_Y_A1_sg13g2_and4_1_X_B_sg13g2_nand4_1_Y_D_sg13g2_nor2_1_Y
+ bist_a\[1\]_sg13g2_dfrbpq_1_Q/Q VDD bist_a\[7\]_sg13g2_dfrbpq_1_Q_D_sg13g2_o21ai_1_Y_A1_sg13g2_o21ai_1_A1_B1_sg13g2_a21oi_1_Y_A2_sg13g2_and2_1_X/B
+ VSS bist_a\[0\]_sg13g2_dfrbpq_1_Q/Q sg13g2_nor2_1
Xscan_reg\[51\]_sg13g2_o21ai_1_A1 VSS VDD scan_reg\[51\]_sg13g2_o21ai_1_A1/Y scan_reg\[51\]_sg13g2_o21ai_1_A1/B1
+ scan_reg\[41\]_sg13g2_nor2_1_A/B scan_reg\[51\]_sg13g2_nor2_1_A/A sg13g2_o21ai_1
Xscan_reg\[19\]_sg13g2_dfrbpq_1_Q VDD scan_reg\[19\]_sg13g2_dfrbpq_1_Q/D scan_reg\[19\]_sg13g2_nor2_1_A/A
+ clkbuf_5_31__f_clk/X VSS rst_n sg13g2_dfrbpq_1
Xcarry_flag_sg13g2_o21ai_1_A1_B1_sg13g2_nand2_1_Y_B_sg13g2_a21oi_1_Y_A2_sg13g2_a21oi_1_Y_B1_sg13g2_o21ai_1_B1_Y_sg13g2_a221oi_1_B1_1_B2_sg13g2_xnor2_1_Y_B_sg13g2_o21ai_1_Y_A1_sg13g2_nand2b_1_A_N_Y_sg13g2_nand4_1_C_B_sg13g2_a22oi_1_Y
+ carry_flag_sg13g2_o21ai_1_A1_B1_sg13g2_nand2_1_Y_B_sg13g2_a21oi_1_Y_A2_sg13g2_a21oi_1_Y_B1_sg13g2_o21ai_1_B1_Y_sg13g2_a221oi_1_B1_1_B2_sg13g2_xnor2_1_Y_B_sg13g2_o21ai_1_Y_A1_sg13g2_nand2b_1_A_N_Y_sg13g2_nand4_1_C/B
+ uo_out_sg13g2_dfrbpq_1_Q_6_D_sg13g2_a21oi_1_Y_A2_sg13g2_a21o_1_X_A2_sg13g2_and2_1_X_A_sg13g2_a221oi_1_Y_C1_sg13g2_nand3_1_Y_C_sg13g2_a221oi_1_Y/A2
+ VDD overflow_flag_sg13g2_dfrbpq_1_Q_D_sg13g2_inv_1_Y_A_sg13g2_o21ai_1_Y_B1_sg13g2_nand3_1_Y_A_sg13g2_and4_1_A_C_sg13g2_o21ai_1_Y/A2
+ serial_b\[1\]_sg13g2_xor2_1_A/X VSS carry_flag_sg13g2_o21ai_1_A1_B1_sg13g2_nand2_1_Y_B_sg13g2_a21oi_1_Y_A2_sg13g2_a21oi_1_Y_B1_sg13g2_o21ai_1_B1_Y_sg13g2_a221oi_1_B1_1_B2_sg13g2_xnor2_1_Y_B_sg13g2_o21ai_1_Y_A1_sg13g2_nand2b_1_A_N_Y_sg13g2_nand4_1_C_B_sg13g2_a22oi_1_Y/B2
+ sg13g2_a22oi_1
Xscan_reg\[52\]_sg13g2_dfrbpq_1_Q_D_sg13g2_a221oi_1_Y_A1_sg13g2_inv_1_Y scan_reg\[52\]_sg13g2_dfrbpq_1_Q_D_sg13g2_a221oi_1_Y/A1
+ cycle_counter\[2\]_sg13g2_dfrbpq_1_Q/Q VSS VDD sg13g2_inv_1
Xscan_reg\[39\]_sg13g2_dfrbpq_1_Q VDD scan_reg\[39\]_sg13g2_dfrbpq_1_Q/D scan_reg\[39\]_sg13g2_inv_1_A/A
+ clkbuf_5_12__f_clk/X VSS rst_n sg13g2_dfrbpq_1
Xmisr\[4\]_sg13g2_inv_1_A_Y_sg13g2_xnor2_1_A_B_sg13g2_o21ai_1_Y_B1_sg13g2_or2_1_X_A_sg13g2_nand3_1_Y_C_sg13g2_a21oi_1_Y_A2_sg13g2_xnor2_1_Y
+ misr\[4\]_sg13g2_inv_1_A_Y_sg13g2_xnor2_1_A_B_sg13g2_o21ai_1_Y_B1_sg13g2_or2_1_X_A_sg13g2_nand3_1_Y_C_sg13g2_a21oi_1_Y/A2
+ misr\[4\]_sg13g2_inv_1_A_Y_sg13g2_xnor2_1_A_B_sg13g2_o21ai_1_Y_B1_sg13g2_or2_1_X_A_sg13g2_nand3_1_Y_C_sg13g2_a21oi_1_Y_A2_sg13g2_xnor2_1_Y/B
+ VDD misr\[1\]_sg13g2_dfrbpq_1_Q_D_sg13g2_a22oi_1_Y_B2_sg13g2_o21ai_1_Y_A2_sg13g2_a22oi_1_Y_A2_sg13g2_and2_1_X_A_sg13g2_a21oi_1_Y/A1
+ VSS sg13g2_xnor2_1
Xoperation\[3\]_sg13g2_dfrbpq_1_Q_D_sg13g2_a21oi_1_Y_A1_sg13g2_a21oi_1_A1_Y_sg13g2_nor2_1_B_Y_sg13g2_a21oi_1_B1_Y_sg13g2_nand3_1_A_B_sg13g2_nand2b_1_Y
+ VSS operation\[3\]_sg13g2_dfrbpq_1_Q_D_sg13g2_a21oi_1_Y_A1_sg13g2_a21oi_1_A1_Y_sg13g2_nor2_1_B_Y_sg13g2_a21oi_1_B1_Y_sg13g2_nand3_1_A_B_sg13g2_nand2b_1_Y/A_N
+ operation\[3\]_sg13g2_dfrbpq_1_Q_D_sg13g2_a21oi_1_Y_A1_sg13g2_a21oi_1_A1_Y_sg13g2_nor2_1_B_Y_sg13g2_a21oi_1_B1_Y_sg13g2_nand3_1_A/B
+ overflow_flag_sg13g2_dfrbpq_1_Q_D_sg13g2_inv_1_Y_A_sg13g2_o21ai_1_Y_B1_sg13g2_nand3_1_Y_A_sg13g2_and4_1_A_C_sg13g2_o21ai_1_Y/A2
+ VDD sg13g2_nand2b_1
Xoperand_a\[1\]_sg13g2_nand2b_1_A_N VSS operand_a\[1\]_sg13g2_mux2_1_A0/A0 scan_reg\[1\]_sg13g2_o21ai_1_A1_1/B1
+ ui_in[3] VDD sg13g2_nand2b_1
Xuo_out_sg13g2_dfrbpq_1_Q_6_D_sg13g2_a21oi_1_Y_A2_sg13g2_a21o_1_X_A2_sg13g2_and2_1_X_B_sg13g2_a22oi_1_Y_B2_sg13g2_and2_1_X
+ uo_out_sg13g2_dfrbpq_1_Q_6_D_sg13g2_a21oi_1_Y_A2_sg13g2_a21o_1_X_A2_sg13g2_and2_1_X_B_sg13g2_a22oi_1_Y/B2
+ VSS VDD uo_out_sg13g2_dfrbpq_1_Q_6_D_sg13g2_a21oi_1_Y_A2_sg13g2_a21o_1_X_A2_sg13g2_and2_1_X_B_sg13g2_a22oi_1_Y_B2_sg13g2_and2_1_X/B
+ uo_out_sg13g2_dfrbpq_1_Q_6_D_sg13g2_a21oi_1_Y_A2_sg13g2_a21o_1_X_A2_sg13g2_and2_1_X_B_sg13g2_a22oi_1_Y_B2_sg13g2_and2_1_X/A
+ sg13g2_and2_1
Xmisr\[1\]_sg13g2_inv_1_A misr\[1\]_sg13g2_inv_1_A/Y misr\[1\]_sg13g2_inv_1_A/A VSS
+ VDD sg13g2_inv_1
Xscan_reg\[5\]_sg13g2_inv_1_A scan_reg\[5\]_sg13g2_inv_1_A/Y scan_reg\[5\]_sg13g2_inv_1_A/A
+ VSS VDD sg13g2_inv_1
Xscan_reg\[31\]_sg13g2_inv_1_A scan_reg\[31\]_sg13g2_inv_1_A/Y scan_reg\[31\]_sg13g2_inv_1_A/A
+ VSS VDD sg13g2_inv_1
Xuo_out_sg13g2_dfrbpq_1_Q_1_D_sg13g2_a21oi_1_Y_A2_sg13g2_o21ai_1_Y_B1_sg13g2_nand2b_1_Y
+ VSS misr\[1\]_sg13g2_inv_1_A_Y_sg13g2_xnor2_1_A_B_sg13g2_o21ai_1_Y/A1 uo_out_sg13g2_dfrbpq_1_Q_1_D_sg13g2_a21oi_1_Y_A2_sg13g2_o21ai_1_Y/B1
+ uo_out_sg13g2_dfrbpq_1_Q_1_D_sg13g2_a21oi_1_Y_A2_sg13g2_o21ai_1_Y_B1_sg13g2_nand2b_1_Y/B
+ VDD sg13g2_nand2b_1
Xoperation\[3\]_sg13g2_dfrbpq_1_Q_D_sg13g2_a21oi_1_Y_A1_sg13g2_a21oi_1_A1_Y_sg13g2_nor2_1_B
+ serial_b\[0\]_sg13g2_xnor2_1_B/Y VDD operation\[3\]_sg13g2_dfrbpq_1_Q_D_sg13g2_a21oi_1_Y_A1_sg13g2_a21oi_1_A1_Y_sg13g2_nor2_1_B/Y
+ VSS operation\[3\]_sg13g2_dfrbpq_1_Q_D_sg13g2_a21oi_1_Y_A1_sg13g2_a21oi_1_A1/Y sg13g2_nor2_1
Xclkload0 clkload0/Y clkload0/A VSS VDD sg13g2_inv_1
Xuo_out_sg13g2_dfrbpq_1_Q_D_sg13g2_a21oi_1_Y_B1_sg13g2_a21oi_1_Y_A1_sg13g2_nand3_1_Y_B_sg13g2_a221oi_1_Y_C1_sg13g2_o21ai_1_Y_A1_sg13g2_nor2_1_B_Y_sg13g2_a22oi_1_B2
+ uo_out_sg13g2_dfrbpq_1_Q_D_sg13g2_a21oi_1_Y_B1_sg13g2_a21oi_1_Y_A1_sg13g2_nand3_1_Y_B_sg13g2_a221oi_1_Y_C1_sg13g2_o21ai_1_Y_A1_sg13g2_nor2_1_B_Y_sg13g2_a22oi_1_B2/Y
+ uo_out_sg13g2_dfrbpq_1_Q_6_D_sg13g2_a21oi_1_Y_A2_sg13g2_a21o_1_X_A2_sg13g2_and2_1_X_B_sg13g2_a22oi_1_Y/A2
+ VDD uo_out_sg13g2_dfrbpq_1_Q_D_sg13g2_a21oi_1_Y_B1_sg13g2_a21oi_1_Y_A1_sg13g2_nand3_1_Y_B_sg13g2_a221oi_1_Y_C1_sg13g2_o21ai_1_Y_A1_sg13g2_nor2_1_B_Y_sg13g2_a22oi_1_B2/B1
+ serial_b\[6\]_sg13g2_and2_1_A/A VSS uo_out_sg13g2_dfrbpq_1_Q_D_sg13g2_a21oi_1_Y_B1_sg13g2_a21oi_1_Y_A1_sg13g2_nand3_1_Y_B_sg13g2_a221oi_1_Y_C1_sg13g2_o21ai_1_Y_A1_sg13g2_nor2_1_B/Y
+ sg13g2_a22oi_1
Xuo_out_sg13g2_dfrbpq_1_Q_6_D_sg13g2_a21oi_1_Y_A2_sg13g2_a21o_1_X uo_out_sg13g2_dfrbpq_1_Q_6_D_sg13g2_a21oi_1_Y_A2_sg13g2_a21o_1_X/B1
+ uo_out_sg13g2_dfrbpq_1_Q_6_D_sg13g2_a21oi_1_Y/A2 VDD VSS uo_out_sg13g2_dfrbpq_1_Q_6_D_sg13g2_a21oi_1_Y_A2_sg13g2_a21o_1_X/A1
+ uo_out_sg13g2_dfrbpq_1_Q_6_D_sg13g2_a21oi_1_Y_A2_sg13g2_a21o_1_X/A2 sg13g2_a21o_1
Xscan_reg\[3\]_sg13g2_o21ai_1_A1 VSS VDD scan_reg\[3\]_sg13g2_o21ai_1_A1/Y scan_reg\[3\]_sg13g2_o21ai_1_A1/B1
+ scan_reg\[41\]_sg13g2_nor2_1_A/B scan_reg\[3\]_sg13g2_nor2_1_A/A sg13g2_o21ai_1
Xclkbuf_5_29__f_clk clkbuf_5_29__f_clk/X VSS clkbuf_4_14_0_clk/X VDD sg13g2_buf_4
Xmisr\[3\]_sg13g2_dfrbpq_1_Q_D_sg13g2_o21ai_1_Y_B1_sg13g2_nand2_1_Y misr\[3\]_sg13g2_dfrbpq_1_Q_D_sg13g2_o21ai_1_Y/B1
+ VDD misr\[3\]_sg13g2_dfrbpq_1_Q/Q VSS misr\[7\]_sg13g2_dfrbpq_1_Q_D_sg13g2_a22oi_1_Y/A2
+ sg13g2_nand2_1
Xlfsr\[4\]_sg13g2_dfrbpq_1_Q_D_sg13g2_inv_1_Y lfsr\[4\]_sg13g2_dfrbpq_1_Q/D lfsr\[4\]_sg13g2_dfrbpq_1_Q_D_sg13g2_inv_1_Y/A
+ VSS VDD sg13g2_inv_1
Xcarry_flag_sg13g2_o21ai_1_A1_B1_sg13g2_nand2_1_Y_A_sg13g2_nand3_1_Y_A_sg13g2_a21oi_1_B1_Y_sg13g2_a221oi_1_B2_C1_sg13g2_o21ai_1_Y_A2_sg13g2_a21oi_1_Y
+ VDD VSS uo_out_sg13g2_dfrbpq_1_Q_6_D_sg13g2_a21oi_1_Y_A2_sg13g2_a21o_1_X_A2_sg13g2_and2_1_X_A_sg13g2_a221oi_1_Y_C1_sg13g2_nand3_1_Y_C_sg13g2_a221oi_1_Y/A2
+ carry_flag_sg13g2_o21ai_1_A1_B1_sg13g2_nand2_1_Y_A_sg13g2_nand3_1_Y_A_sg13g2_a21oi_1_B1_Y_sg13g2_a221oi_1_B2_C1_sg13g2_o21ai_1_Y_A2_sg13g2_a21oi_1_Y/A1
+ serial_opcode\[2\]_sg13g2_nor3_1_A/Y carry_flag_sg13g2_o21ai_1_A1_B1_sg13g2_nand2_1_Y_A_sg13g2_nand3_1_Y_A_sg13g2_a21oi_1_B1_Y_sg13g2_a221oi_1_B2_C1_sg13g2_o21ai_1_Y/A2
+ sg13g2_a21oi_1
Xmisr\[4\]_sg13g2_a22oi_1_B2_A2_sg13g2_nor2b_1_Y uio_in[6] uio_in[7] VDD misr\[4\]_sg13g2_a22oi_1_B2/A2
+ VSS sg13g2_nor2b_1
Xscan_reg\[57\]_sg13g2_dfrbpq_1_Q_D_sg13g2_a21oi_1_Y VDD VSS scan_reg\[57\]_sg13g2_dfrbpq_1_Q_D_sg13g2_a21oi_1_Y/A2
+ scan_reg\[41\]_sg13g2_nor2_1_A/B scan_reg\[57\]_sg13g2_nor2_1_A/Y scan_reg\[57\]_sg13g2_dfrbpq_1_Q/D
+ sg13g2_a21oi_1
Xmisr\[4\]_sg13g2_inv_1_A_Y_sg13g2_xnor2_1_A_B_sg13g2_o21ai_1_Y_B1_sg13g2_or2_1_X_A_sg13g2_nand3_1_Y_A_sg13g2_a221oi_1_Y
+ bist_a\[7\]_sg13g2_dfrbpq_1_Q_D_sg13g2_o21ai_1_Y_A1_sg13g2_nand2_1_A_B_sg13g2_o21ai_1_A2/Y
+ misr\[4\]_sg13g2_inv_1_A_Y_sg13g2_xnor2_1_A_B_sg13g2_o21ai_1_Y_B1_sg13g2_or2_1_X_A_sg13g2_nand3_1_Y/A
+ lfsr\[6\]_sg13g2_mux2_1_A1/A0 misr\[3\]_sg13g2_dfrbpq_1_Q_D_sg13g2_o21ai_1_Y_A2_sg13g2_xnor2_1_Y_B_sg13g2_a22oi_1_Y_A2_sg13g2_a21oi_1_Y/A2
+ bist_a\[7\]_sg13g2_dfrbpq_1_Q_D_sg13g2_o21ai_1_Y_A1_sg13g2_nand2_1_A_Y_sg13g2_a221oi_1_A1/B1
+ VDD bist_a\[4\]_sg13g2_dfrbpq_1_Q/Q VSS sg13g2_a221oi_1
Xcarry_flag_sg13g2_o21ai_1_A1_B1_sg13g2_nand2_1_Y_A_sg13g2_nand3_1_Y_B_sg13g2_nand3_1_C_A_sg13g2_nor2b_1_Y
+ serial_opcode\[2\]_sg13g2_nand2_1_A/Y serial_opcode\[1\]_sg13g2_nor2_1_A/Y VDD carry_flag_sg13g2_o21ai_1_A1_B1_sg13g2_nand2_1_Y_A_sg13g2_nand3_1_Y_B_sg13g2_nand3_1_C/A
+ VSS sg13g2_nor2b_1
Xclkbuf_5_12__f_clk clkbuf_5_12__f_clk/X VSS clkbuf_4_6_0_clk/X VDD sg13g2_buf_4
Xoperation\[2\]_sg13g2_dfrbpq_1_Q_D_sg13g2_o21ai_1_Y_B1_sg13g2_nand2_1_Y operation\[2\]_sg13g2_dfrbpq_1_Q_D_sg13g2_o21ai_1_Y/B1
+ VDD serial_opcode\[2\]_sg13g2_inv_1_A/A VSS ui_in[2] sg13g2_nand2_1
Xbist_pattern_count\[4\]_sg13g2_dfrbpq_1_Q_D_sg13g2_nor3_1_Y_C_sg13g2_nor2_1_Y bist_pattern_count\[4\]_sg13g2_and2_1_A/A
+ VDD bist_pattern_count\[4\]_sg13g2_dfrbpq_1_Q_D_sg13g2_nor3_1_Y/C VSS bist_pattern_count\[4\]_sg13g2_and2_1_A/B
+ sg13g2_nor2_1
Xbist_a\[3\]_sg13g2_dfrbpq_1_Q_D_sg13g2_o21ai_1_Y_B1_sg13g2_nand2_1_Y bist_a\[3\]_sg13g2_dfrbpq_1_Q_D_sg13g2_o21ai_1_Y/B1
+ VDD lfsr\[7\]_sg13g2_xnor2_1_B/A VSS lfsr\[7\]_sg13g2_nand2_1_A/B sg13g2_nand2_1
Xscan_reg\[36\]_sg13g2_inv_1_A scan_reg\[36\]_sg13g2_inv_1_A/Y scan_reg\[36\]_sg13g2_inv_1_A/A
+ VSS VDD sg13g2_inv_1
Xcarry_flag_sg13g2_o21ai_1_A1_B1_sg13g2_nand2_1_Y_A_sg13g2_nand3_1_Y_B_sg13g2_nand3_1_C_Y_sg13g2_o21ai_1_B1_A2_sg13g2_nor3_1_Y_C_sg13g2_nor4_1_Y
+ VSS VDD serial_b\[1\]_sg13g2_xor2_1_A/X carry_flag_sg13g2_o21ai_1_A1_B1_sg13g2_nand2_1_Y_A_sg13g2_nand3_1_Y_B_sg13g2_nand3_1_C_Y_sg13g2_o21ai_1_B1_A2_sg13g2_nor3_1_Y_C_sg13g2_nor4_1_Y/C
+ carry_flag_sg13g2_o21ai_1_A1_B1_sg13g2_nand2_1_Y_A_sg13g2_nand3_1_Y_B_sg13g2_nand3_1_C_Y_sg13g2_o21ai_1_B1_A2_sg13g2_nor3_1_Y/C
+ serial_b\[2\]_sg13g2_xor2_1_A/X carry_flag_sg13g2_o21ai_1_A1_B1_sg13g2_nand2_1_Y_A_sg13g2_nand3_1_Y_B_sg13g2_nand3_1_C_Y_sg13g2_o21ai_1_B1_A2_sg13g2_nor3_1_Y_C_sg13g2_nor4_1_Y/D
+ sg13g2_nor4_1
Xcarry_flag_sg13g2_o21ai_1_A1_B1_sg13g2_nand2_1_Y_A_sg13g2_nand3_1_Y_A_sg13g2_a21oi_1_B1_Y_sg13g2_a221oi_1_B2_C1_sg13g2_o21ai_1_Y_A2_sg13g2_a21oi_1_Y_A1_sg13g2_nand2_1_Y
+ carry_flag_sg13g2_o21ai_1_A1_B1_sg13g2_nand2_1_Y_A_sg13g2_nand3_1_Y_A_sg13g2_a21oi_1_B1_Y_sg13g2_a221oi_1_B2_C1_sg13g2_o21ai_1_Y_A2_sg13g2_a21oi_1_Y/A1
+ VDD serial_a\[3\]_sg13g2_dfrbpq_1_Q/Q VSS serial_b\[3\]_sg13g2_inv_1_A/A sg13g2_nand2_1
Xcarry_flag_sg13g2_o21ai_1_A1_B1_sg13g2_nand2_1_Y_B_sg13g2_a21oi_1_Y_A2_sg13g2_a21oi_1_Y_B1_sg13g2_o21ai_1_B1_Y_sg13g2_a221oi_1_B1_1_Y_sg13g2_or4_1_C_B_sg13g2_nor3_1_Y
+ uo_out_sg13g2_dfrbpq_1_Q_3_D_sg13g2_o21ai_1_Y_B1_sg13g2_nand2_1_Y_B_sg13g2_a22oi_1_Y_A1_sg13g2_a221oi_1_Y_C1_sg13g2_or4_1_X_D_sg13g2_nor3_1_Y/B
+ carry_flag_sg13g2_o21ai_1_A1_B1_sg13g2_nand2_1_Y_B_sg13g2_a21oi_1_Y_A2_sg13g2_a21oi_1_Y_B1_sg13g2_o21ai_1_B1_Y_sg13g2_a221oi_1_B1_1_Y_sg13g2_or4_1_C/B
+ carry_flag_sg13g2_o21ai_1_A1_B1_sg13g2_nand2_1_Y_A_sg13g2_nand3_1_Y_B_sg13g2_nand3_1_Y_A_sg13g2_nor3_1_A/Y
+ carry_flag_sg13g2_o21ai_1_A1_B1_sg13g2_nand2_1_Y_B_sg13g2_a21oi_1_Y_A2_sg13g2_a21oi_1_Y_B1_sg13g2_o21ai_1_B1_Y_sg13g2_a221oi_1_B1_1_Y_sg13g2_or4_1_C_B_sg13g2_nor3_1_Y/C
+ VDD VSS sg13g2_nor3_1
Xmisr\[1\]_sg13g2_inv_1_A_Y_sg13g2_xnor2_1_A_B_sg13g2_o21ai_1_Y_A2_sg13g2_nand3_1_Y_C_sg13g2_a22oi_1_Y_B1_sg13g2_and2_1_X_A_sg13g2_or3_1_X_A_sg13g2_xnor2_1_Y
+ misr\[1\]_sg13g2_inv_1_A_Y_sg13g2_xnor2_1_A_B_sg13g2_o21ai_1_Y_A2_sg13g2_nand3_1_Y_C_sg13g2_a22oi_1_Y_B1_sg13g2_and2_1_X_A_sg13g2_or3_1_X/A
+ lfsr\[6\]_sg13g2_mux2_1_A1/A0 VDD bist_a\[2\]_sg13g2_dfrbpq_1_Q/Q VSS sg13g2_xnor2_1
Xoverflow_flag_sg13g2_dfrbpq_1_Q_D_sg13g2_inv_1_Y_A_sg13g2_o21ai_1_Y_B1_sg13g2_nand3_1_Y_C_sg13g2_a21oi_1_Y_A1_sg13g2_o21ai_1_A2_B1_sg13g2_o21ai_1_A1_Y_sg13g2_nor2_1_B_A_sg13g2_nand3_1_Y_B_sg13g2_nand2_1_Y
+ overflow_flag_sg13g2_dfrbpq_1_Q_D_sg13g2_inv_1_Y_A_sg13g2_o21ai_1_Y_B1_sg13g2_nand3_1_Y_C_sg13g2_a21oi_1_Y_A1_sg13g2_o21ai_1_A2_B1_sg13g2_o21ai_1_A1_Y_sg13g2_nor2_1_B_A_sg13g2_nand3_1_Y/B
+ VDD serial_b\[2\]_sg13g2_xor2_1_A/X VSS uo_out_sg13g2_dfrbpq_1_Q_6_D_sg13g2_a21oi_1_Y_A2_sg13g2_a21o_1_X_A2_sg13g2_and2_1_X_A_sg13g2_a221oi_1_Y_C1_sg13g2_nand3_1_Y_C_sg13g2_a221oi_1_Y/A2
+ sg13g2_nand2_1
Xuo_out_sg13g2_dfrbpq_1_Q_1_D_sg13g2_a21oi_1_Y_A2_sg13g2_o21ai_1_Y_A1_sg13g2_o21ai_1_Y
+ VSS VDD uo_out_sg13g2_dfrbpq_1_Q_1_D_sg13g2_a21oi_1_Y_A2_sg13g2_o21ai_1_Y/A1 uo_out_sg13g2_dfrbpq_1_Q_1_D_sg13g2_a21oi_1_Y_A2_sg13g2_o21ai_1_Y_A1_sg13g2_o21ai_1_Y/B1
+ uo_out_sg13g2_dfrbpq_1_Q_2_D_sg13g2_o21ai_1_Y_B1_sg13g2_nand3_1_Y_B_sg13g2_nand2_1_Y/A
+ misr\[4\]_sg13g2_inv_1_A_Y_sg13g2_xnor2_1_A_B_sg13g2_o21ai_1_Y_A1_sg13g2_a21oi_1_Y/B1
+ sg13g2_o21ai_1
Xuo_out_sg13g2_dfrbpq_1_Q_D_sg13g2_a21oi_1_Y_B1_sg13g2_a21oi_1_Y_A1_sg13g2_nand3_1_Y_B_sg13g2_a221oi_1_Y_C1_sg13g2_o21ai_1_Y_A1_sg13g2_nor2_1_B_Y_sg13g2_a22oi_1_B2_B1_sg13g2_nand3_1_Y_C_sg13g2_a21o_1_X
+ uo_out_sg13g2_dfrbpq_1_Q_5_D_sg13g2_a21oi_1_Y_A2_sg13g2_o21ai_1_Y_B1_sg13g2_or2_1_X_B_sg13g2_nand2_1_Y_B_sg13g2_a22oi_1_Y_B1_sg13g2_nand3_1_Y/B
+ uo_out_sg13g2_dfrbpq_1_Q_D_sg13g2_a21oi_1_Y_B1_sg13g2_a21oi_1_Y_A1_sg13g2_nand3_1_Y_B_sg13g2_a221oi_1_Y_C1_sg13g2_o21ai_1_Y_A1_sg13g2_nor2_1_B_Y_sg13g2_a22oi_1_B2_B1_sg13g2_nand3_1_Y/C
+ VDD VSS serial_b\[4\]_sg13g2_nand2_1_A/Y uo_out_sg13g2_dfrbpq_1_Q_6_D_sg13g2_a21oi_1_Y_A2_sg13g2_a21o_1_X_A2_sg13g2_and2_1_X_B_sg13g2_a22oi_1_Y_B2_sg13g2_and2_1_X/A
+ sg13g2_a21o_1
Xfault_counter\[3\]_sg13g2_dfrbpq_1_Q_D_sg13g2_nor2_1_Y fault_counter\[3\]_sg13g2_dfrbpq_1_Q_D_sg13g2_nor2_1_Y/A
+ VDD fault_counter\[3\]_sg13g2_dfrbpq_1_Q/D VSS fault_counter\[3\]_sg13g2_dfrbpq_1_Q_D_sg13g2_nor2_1_Y/B
+ sg13g2_nor2_1
Xoverflow_flag_sg13g2_dfrbpq_1_Q_D_sg13g2_inv_1_Y_A_sg13g2_o21ai_1_Y_B1_sg13g2_nand3_1_Y_A_sg13g2_nand2_1_Y_B_sg13g2_a21oi_1_Y_A2_sg13g2_nand3_1_C
+ VDD uo_out_sg13g2_dfrbpq_1_Q_D_sg13g2_a21oi_1_Y_B1_sg13g2_a21oi_1_Y_A1_sg13g2_nand3_1_Y_B_sg13g2_a221oi_1_Y_C1_sg13g2_o21ai_1_Y_A1_sg13g2_a21oi_1_Y/A2
+ overflow_flag_sg13g2_dfrbpq_1_Q_D_sg13g2_inv_1_Y_A_sg13g2_o21ai_1_Y_B1_sg13g2_nand3_1_Y_A_sg13g2_and4_1_A_C_sg13g2_o21ai_1_Y/B1
+ overflow_flag_sg13g2_dfrbpq_1_Q_D_sg13g2_inv_1_Y_A_sg13g2_o21ai_1_Y_B1_sg13g2_nand3_1_Y_A_sg13g2_nand2_1_Y_B_sg13g2_a21oi_1_Y/A2
+ serial_b\[6\]_sg13g2_nand2_1_A/Y VSS sg13g2_nand3_1
Xuo_out_sg13g2_dfrbpq_1_Q_5_D_sg13g2_a21oi_1_Y_A2_sg13g2_o21ai_1_Y_B1_sg13g2_or2_1_X_B_sg13g2_nand2_1_Y_A_sg13g2_a221oi_1_Y_B2_sg13g2_xor2_1_X_A_sg13g2_nand2_1_Y_A_sg13g2_nand2b_1_Y
+ VSS serial_b\[4\]_sg13g2_nand2_1_A/A uo_out_sg13g2_dfrbpq_1_Q_5_D_sg13g2_a21oi_1_Y_A2_sg13g2_o21ai_1_Y_B1_sg13g2_or2_1_X_B_sg13g2_nand2_1_Y_A_sg13g2_a221oi_1_Y_B2_sg13g2_xor2_1_X_A_sg13g2_nand2_1_Y/A
+ serial_b\[4\]_sg13g2_nand2_1_A/B VDD sg13g2_nand2b_1
Xbist_a\[7\]_sg13g2_dfrbpq_1_Q_D_sg13g2_o21ai_1_Y_A1_sg13g2_o21ai_1_A1_B1_sg13g2_nand4_1_C_Y_sg13g2_a221oi_1_C1
+ bist_a\[7\]_sg13g2_dfrbpq_1_Q_D_sg13g2_o21ai_1_Y_A1_sg13g2_o21ai_1_A1_B1_sg13g2_nand4_1_C/Y
+ bist_a\[7\]_sg13g2_dfrbpq_1_Q_D_sg13g2_o21ai_1_Y_A1_sg13g2_o21ai_1_A1_B1_sg13g2_nand4_1_C_Y_sg13g2_a221oi_1_C1/Y
+ bist_a\[7\]_sg13g2_dfrbpq_1_Q_D_sg13g2_o21ai_1_Y_A1_sg13g2_nand2_1_A_Y_sg13g2_a221oi_1_B2/A1
+ bist_a\[7\]_sg13g2_dfrbpq_1_Q_D_sg13g2_o21ai_1_Y_A1_sg13g2_o21ai_1_A1_B1_sg13g2_nand4_1_C_Y_sg13g2_a221oi_1_C1/B1
+ bist_a\[7\]_sg13g2_dfrbpq_1_Q_D_sg13g2_o21ai_1_Y_A1_sg13g2_o21ai_1_A1_B1_sg13g2_nand4_1_C_Y_sg13g2_a221oi_1_C1/A2
+ VDD bist_a\[7\]_sg13g2_dfrbpq_1_Q_D_sg13g2_o21ai_1_Y_A1_sg13g2_nand2_1_A_Y_sg13g2_a221oi_1_A1/C1
+ VSS sg13g2_a221oi_1
Xuio_out_sg13g2_nand2_1_Y_6_B_sg13g2_a22oi_1_Y uio_out_sg13g2_nand2_1_Y_6/B bist_done_sg13g2_a22oi_1_B2/A2
+ VDD misr\[1\]_sg13g2_a22oi_1_B2/A2 cycle_counter\[5\]_sg13g2_dfrbpq_1_Q/Q VSS uio_out_sg13g2_nand2_1_Y_6_B_sg13g2_a22oi_1_Y/B2
+ sg13g2_a22oi_1
Xscan_reg\[22\]_sg13g2_inv_1_A scan_reg\[22\]_sg13g2_inv_1_A/Y scan_reg\[22\]_sg13g2_inv_1_A/A
+ VSS VDD sg13g2_inv_1
Xmisr\[6\]_sg13g2_dfrbpq_1_Q_D_sg13g2_o21ai_1_Y_A2_sg13g2_xnor2_1_Y_B_sg13g2_a22oi_1_Y
+ misr\[6\]_sg13g2_dfrbpq_1_Q_D_sg13g2_o21ai_1_Y_A2_sg13g2_xnor2_1_Y/B uo_out_sg13g2_dfrbpq_1_Q_4_D_sg13g2_a21oi_1_Y_A2_sg13g2_a21o_1_X_B1_sg13g2_and2_1_X/A
+ VDD uo_out_sg13g2_dfrbpq_1_Q_4_D_sg13g2_a21oi_1_Y_A2_sg13g2_a21o_1_X_A2_sg13g2_a21o_1_X/B1
+ misr\[6\]_sg13g2_dfrbpq_1_Q_D_sg13g2_o21ai_1_Y_A2_sg13g2_xnor2_1_Y_B_sg13g2_a22oi_1_Y/A1
+ VSS misr\[6\]_sg13g2_dfrbpq_1_Q_D_sg13g2_o21ai_1_Y_A2_sg13g2_xnor2_1_Y_B_sg13g2_a22oi_1_Y/B2
+ sg13g2_a22oi_1
Xuo_out_sg13g2_dfrbpq_1_Q_6_D_sg13g2_a21oi_1_Y_A2_sg13g2_a21o_1_X_A2_sg13g2_and2_1_X_A_sg13g2_a221oi_1_Y_C1_sg13g2_nand3_1_Y_C_sg13g2_a221oi_1_Y_C1_sg13g2_o21ai_1_Y
+ VSS VDD uo_out_sg13g2_dfrbpq_1_Q_6_D_sg13g2_a21oi_1_Y_A2_sg13g2_a21o_1_X_A2_sg13g2_and2_1_X_A_sg13g2_a221oi_1_Y_C1_sg13g2_nand3_1_Y_C_sg13g2_a221oi_1_Y/C1
+ uo_out_sg13g2_dfrbpq_1_Q_6_D_sg13g2_a21oi_1_Y_A2_sg13g2_a21o_1_X_A2_sg13g2_and2_1_X_A_sg13g2_a221oi_1_Y_C1_sg13g2_nand3_1_Y_C_sg13g2_a221oi_1_Y_C1_sg13g2_o21ai_1_Y/B1
+ overflow_flag_sg13g2_dfrbpq_1_Q_D_sg13g2_inv_1_Y_A_sg13g2_o21ai_1_Y_B1_sg13g2_nand3_1_Y_A_sg13g2_and4_1_A_B_sg13g2_or2_1_X/B
+ serial_b\[4\]_sg13g2_nand2_1_A/B sg13g2_o21ai_1
Xmisr\[4\]_sg13g2_inv_1_A_Y_sg13g2_xnor2_1_A_B_sg13g2_o21ai_1_Y_B1_sg13g2_or2_1_X_A_sg13g2_nand3_1_Y_C_sg13g2_a21oi_1_Y_A2_sg13g2_xnor2_1_Y_B_sg13g2_a21oi_1_Y
+ VDD VSS bist_a\[4\]_sg13g2_dfrbpq_1_Q/Q bist_a\[0\]_sg13g2_dfrbpq_1_Q/Q bist_a\[7\]_sg13g2_dfrbpq_1_Q_D_sg13g2_o21ai_1_Y_A1_sg13g2_o21ai_1_A1_B1_sg13g2_nand4_1_C_Y_sg13g2_a221oi_1_C1_B1_sg13g2_nor2_1_Y/A
+ misr\[4\]_sg13g2_inv_1_A_Y_sg13g2_xnor2_1_A_B_sg13g2_o21ai_1_Y_B1_sg13g2_or2_1_X_A_sg13g2_nand3_1_Y_C_sg13g2_a21oi_1_Y_A2_sg13g2_xnor2_1_Y/B
+ sg13g2_a21oi_1
Xuo_out_sg13g2_dfrbpq_1_Q_1_D_sg13g2_a21oi_1_Y_A2_sg13g2_o21ai_1_Y_A2_sg13g2_o21ai_1_Y_A2_sg13g2_and2_1_X_B_sg13g2_nor2b_1_Y
+ uio_in[3] uio_in[4] VDD uo_out_sg13g2_dfrbpq_1_Q_1_D_sg13g2_a21oi_1_Y_A2_sg13g2_o21ai_1_Y_A2_sg13g2_o21ai_1_Y_A2_sg13g2_and2_1_X/B
+ VSS sg13g2_nor2b_1
Xscan_reg\[57\]_sg13g2_nor2_1_A scan_reg\[57\]_sg13g2_nor2_1_A/A VDD scan_reg\[57\]_sg13g2_nor2_1_A/Y
+ VSS ui_in[3] sg13g2_nor2_1
Xuo_out_sg13g2_dfrbpq_1_Q_6_D_sg13g2_a21oi_1_Y_A2_sg13g2_a21o_1_X_A2_sg13g2_and2_1_X_A_sg13g2_a221oi_1_Y_C1_sg13g2_nand3_1_Y_B_sg13g2_a22oi_1_Y
+ uo_out_sg13g2_dfrbpq_1_Q_6_D_sg13g2_a21oi_1_Y_A2_sg13g2_a21o_1_X_A2_sg13g2_and2_1_X_A_sg13g2_a221oi_1_Y_C1_sg13g2_nand3_1_Y/B
+ overflow_flag_sg13g2_dfrbpq_1_Q_D_sg13g2_inv_1_Y_A_sg13g2_o21ai_1_Y_B1_sg13g2_nand3_1_Y_A_sg13g2_and4_1_A_D_sg13g2_a221oi_1_Y/A2
+ VDD serial_opcode\[0\]_sg13g2_o21ai_1_A1/Y serial_a\[3\]_sg13g2_dfrbpq_1_Q/Q VSS
+ serial_a\[5\]_sg13g2_dfrbpq_1_Q/Q sg13g2_a22oi_1
Xcycle_counter\[5\]_sg13g2_dfrbpq_1_Q VDD cycle_counter\[5\]_sg13g2_dfrbpq_1_Q/D cycle_counter\[5\]_sg13g2_dfrbpq_1_Q/Q
+ clkbuf_5_14__f_clk/X VSS rst_n sg13g2_dfrbpq_1
Xbist_pattern_count\[2\]_sg13g2_dfrbpq_1_Q_D_sg13g2_nor3_1_Y_C_sg13g2_nor2_1_Y bist_pattern_count\[3\]_sg13g2_nand4_1_D/C
+ VDD bist_pattern_count\[2\]_sg13g2_dfrbpq_1_Q_D_sg13g2_nor3_1_Y/C VSS bist_pattern_count\[1\]_sg13g2_and3_1_A/X
+ sg13g2_nor2_1
Xoverflow_flag_sg13g2_dfrbpq_1_Q_D_sg13g2_inv_1_Y_A_sg13g2_o21ai_1_Y_B1_sg13g2_nand3_1_Y_A_sg13g2_and4_1_A_B_sg13g2_or2_1_X_B_sg13g2_nand2_1_Y
+ overflow_flag_sg13g2_dfrbpq_1_Q_D_sg13g2_inv_1_Y_A_sg13g2_o21ai_1_Y_B1_sg13g2_nand3_1_Y_A_sg13g2_and4_1_A_B_sg13g2_or2_1_X/B
+ VDD serial_opcode\[1\]_sg13g2_nor2b_1_A/Y VSS serial_opcode\[3\]_sg13g2_nor2_1_B/Y
+ sg13g2_nand2_1
Xbist_a\[1\]_sg13g2_dfrbpq_1_Q_D_sg13g2_o21ai_1_Y_A1_sg13g2_inv_1_Y bist_a\[1\]_sg13g2_dfrbpq_1_Q_D_sg13g2_o21ai_1_Y/A1
+ bist_a\[1\]_sg13g2_dfrbpq_1_Q/Q VSS VDD sg13g2_inv_1
Xclkload1 clkload1/Y clkload1/A VSS VDD sg13g2_inv_1
Xoperand_a\[3\]_sg13g2_dfrbpq_1_Q VDD operand_a\[3\]_sg13g2_mux2_1_A0/X operand_a\[3\]_sg13g2_mux2_1_A0/A0
+ clkload1/A VSS rst_n sg13g2_dfrbpq_1
Xmisr\[6\]_sg13g2_dfrbpq_1_Q_D_sg13g2_o21ai_1_Y_A2_sg13g2_xnor2_1_Y_B_sg13g2_a22oi_1_Y_B1_sg13g2_nor2b_1_Y
+ uo_out_sg13g2_dfrbpq_1_Q_4_D_sg13g2_a21oi_1_Y_A2_sg13g2_a21o_1_X_B1_sg13g2_and2_1_X/A
+ misr\[1\]_sg13g2_inv_1_A_Y_sg13g2_xnor2_1_A_B_sg13g2_o21ai_1_Y_B1_sg13g2_nand4_1_Y/A
+ VDD uo_out_sg13g2_dfrbpq_1_Q_4_D_sg13g2_a21oi_1_Y_A2_sg13g2_a21o_1_X_A2_sg13g2_a21o_1_X/B1
+ VSS sg13g2_nor2b_1
Xbist_pattern_count\[1\]_sg13g2_and3_1_A bist_pattern_count\[1\]_sg13g2_and3_1_A/X
+ bist_pattern_count\[1\]_sg13g2_and3_1_A/B VDD VSS bist_pattern_count\[1\]_sg13g2_and3_1_A/C
+ bist_pattern_count\[1\]_sg13g2_and3_1_A/A sg13g2_and3_1
Xbist_fault_sg13g2_dfrbpq_1_Q VDD bist_fault_sg13g2_dfrbpq_1_Q/D bist_fault_sg13g2_nor2_1_B/B
+ clkbuf_5_8__f_clk/X VSS rst_n sg13g2_dfrbpq_1
Xoperand_a\[6\]_sg13g2_nand2b_1_A_N VSS operand_a\[6\]_sg13g2_mux2_1_A0/A0 scan_reg\[6\]_sg13g2_o21ai_1_A1_1/B1
+ ui_in[3] VDD sg13g2_nand2b_1
Xmisr\[1\]_sg13g2_dfrbpq_1_Q_D_sg13g2_a22oi_1_Y_B2_sg13g2_o21ai_1_Y_A2_sg13g2_a22oi_1_Y_A2_sg13g2_and2_1_X_A_sg13g2_a21oi_1_Y_A1_sg13g2_xor2_1_X
+ misr\[1\]_sg13g2_dfrbpq_1_Q_D_sg13g2_a22oi_1_Y_B2_sg13g2_o21ai_1_Y_A2_sg13g2_a22oi_1_Y_A2_sg13g2_and2_1_X_A_sg13g2_a21oi_1_Y/A1
+ VDD bist_a\[5\]_sg13g2_dfrbpq_1_Q/Q bist_a\[1\]_sg13g2_dfrbpq_1_Q/Q VSS sg13g2_xor2_1
Xscan_reg\[30\]_sg13g2_dfrbpq_1_Q_D_sg13g2_o21ai_1_Y VSS VDD scan_reg\[30\]_sg13g2_dfrbpq_1_Q/D
+ scan_reg\[30\]_sg13g2_a22oi_1_B1/Y scan_reg\[3\]_sg13g2_nor2_1_A/B scan_reg\[31\]_sg13g2_inv_1_A/Y
+ sg13g2_o21ai_1
Xuo_out_sg13g2_dfrbpq_1_Q_5_D_sg13g2_a21oi_1_Y_A2_sg13g2_o21ai_1_Y_B1_sg13g2_or2_1_X_B_sg13g2_nand2_1_Y_A_sg13g2_a221oi_1_Y_B2_sg13g2_xor2_1_X_A_sg13g2_nand2_1_Y_A_sg13g2_nand3_1_B
+ VDD uo_out_sg13g2_dfrbpq_1_Q_5_D_sg13g2_a21oi_1_Y_A2_sg13g2_o21ai_1_Y_B1_sg13g2_or2_1_X_B_sg13g2_nand2_1_Y_A_sg13g2_a221oi_1_Y_B2_sg13g2_xor2_1_X_A_sg13g2_nand2_1_Y_A_sg13g2_nand3_1_B/Y
+ uo_out_sg13g2_dfrbpq_1_Q_5_D_sg13g2_a21oi_1_Y_A2_sg13g2_o21ai_1_Y_B1_sg13g2_or2_1_X_B_sg13g2_nand2_1_Y_A_sg13g2_a221oi_1_Y_B2_sg13g2_xor2_1_X_A_sg13g2_nand2_1_Y/A
+ uo_out_sg13g2_dfrbpq_1_Q_6_D_sg13g2_a21oi_1_Y_A2_sg13g2_a21o_1_X_A2_sg13g2_and2_1_X_A_sg13g2_a221oi_1_Y_B2_sg13g2_and2_1_X/A
+ uo_out_sg13g2_dfrbpq_1_Q_5_D_sg13g2_a21oi_1_Y_A2_sg13g2_o21ai_1_Y_B1_sg13g2_or2_1_X_B_sg13g2_nand2_1_Y_A_sg13g2_a221oi_1_Y_B2_sg13g2_xor2_1_X_A_sg13g2_nand2_1_Y_A_sg13g2_nand3_1_B/A
+ VSS sg13g2_nand3_1
Xscan_reg\[0\]_sg13g2_dfrbpq_1_Q VDD scan_reg\[0\]_sg13g2_dfrbpq_1_Q/D scan_out_sg13g2_a22oi_1_A1/B2
+ clkbuf_5_7__f_clk/X VSS rst_n sg13g2_dfrbpq_1
Xmisr\[1\]_sg13g2_inv_1_A_Y_sg13g2_xnor2_1_A_B_sg13g2_o21ai_1_Y_A2_sg13g2_nand3_1_Y_C_sg13g2_a22oi_1_Y_A1_sg13g2_and2_1_X
+ misr\[1\]_sg13g2_inv_1_A_Y_sg13g2_xnor2_1_A_B_sg13g2_o21ai_1_Y_A2_sg13g2_nand3_1_Y_C_sg13g2_a22oi_1_Y/A1
+ VSS VDD bist_a\[7\]_sg13g2_dfrbpq_1_Q_D_sg13g2_o21ai_1_Y_A1_sg13g2_o21ai_1_A1_Y_sg13g2_nand2b_1_A_N_B_sg13g2_a21oi_1_Y/A2
+ bist_a\[0\]_sg13g2_dfrbpq_1_Q/Q sg13g2_and2_1
Xoperand_b\[5\]_sg13g2_inv_1_A operand_b\[5\]_sg13g2_inv_1_A/Y operand_b\[5\]_sg13g2_inv_1_A/A
+ VSS VDD sg13g2_inv_1
Xscan_reg\[11\]_sg13g2_dfrbpq_1_Q_D_sg13g2_a21oi_1_Y VDD VSS scan_out_sg13g2_a22oi_1_A1/B1
+ scan_reg\[12\]_sg13g2_inv_1_A/Y scan_reg\[11\]_sg13g2_o21ai_1_A1_1/Y scan_reg\[11\]_sg13g2_dfrbpq_1_Q/D
+ sg13g2_a21oi_1
Xcarry_flag_sg13g2_o21ai_1_A1_B1_sg13g2_nand2_1_Y_A_sg13g2_nand3_1_Y_A_sg13g2_a21oi_1_B1_Y_sg13g2_a221oi_1_B2_C1_sg13g2_o21ai_1_Y_B1_sg13g2_a221oi_1_Y_C1_sg13g2_o21ai_1_Y
+ VSS VDD carry_flag_sg13g2_o21ai_1_A1_B1_sg13g2_nand2_1_Y_A_sg13g2_nand3_1_Y_A_sg13g2_a21oi_1_B1_Y_sg13g2_a221oi_1_B2_C1_sg13g2_o21ai_1_Y_B1_sg13g2_a221oi_1_Y/C1
+ carry_flag_sg13g2_o21ai_1_A1_B1_sg13g2_nand2_1_Y_A_sg13g2_nand3_1_Y_A_sg13g2_a21oi_1_B1_Y_sg13g2_a221oi_1_B2_C1_sg13g2_o21ai_1_Y_B1_sg13g2_a221oi_1_Y_C1_sg13g2_o21ai_1_Y/B1
+ overflow_flag_sg13g2_dfrbpq_1_Q_D_sg13g2_inv_1_Y_A_sg13g2_o21ai_1_Y_B1_sg13g2_nand3_1_Y_A_sg13g2_and4_1_A_B_sg13g2_or2_1_X/B
+ serial_a\[3\]_sg13g2_dfrbpq_1_Q/Q sg13g2_o21ai_1
Xbist_pattern_count\[5\]_sg13g2_dfrbpq_1_Q_D_sg13g2_nor2_1_Y bist_fault_sg13g2_dfrbpq_1_Q_D_sg13g2_nor3_1_Y/A
+ VDD bist_pattern_count\[5\]_sg13g2_dfrbpq_1_Q/D VSS bist_pattern_count\[5\]_sg13g2_dfrbpq_1_Q_D_sg13g2_nor2_1_Y/B
+ sg13g2_nor2_1
Xfault_counter\[2\]_sg13g2_dfrbpq_1_Q VDD fault_counter\[2\]_sg13g2_dfrbpq_1_Q/D fault_counter\[2\]_sg13g2_dfrbpq_1_Q/Q
+ clkbuf_5_14__f_clk/X VSS rst_n sg13g2_dfrbpq_1
Xbist_a\[7\]_sg13g2_dfrbpq_1_Q_D_sg13g2_o21ai_1_Y_A1_sg13g2_o21ai_1_A1_Y_sg13g2_nand2b_1_A_N_Y_sg13g2_a221oi_1_C1_B1_sg13g2_mux2_1_X
+ bist_a\[0\]_sg13g2_dfrbpq_1_Q/Q bist_a\[7\]_sg13g2_dfrbpq_1_Q_D_sg13g2_o21ai_1_Y_A1_sg13g2_o21ai_1_A1_B1_sg13g2_nand4_1_C_Y_sg13g2_a221oi_1_C1/A2
+ bist_a\[7\]_sg13g2_dfrbpq_1_Q_D_sg13g2_o21ai_1_Y_A1_sg13g2_o21ai_1_A1_Y_sg13g2_nand2b_1_A_N_Y_sg13g2_a221oi_1_C1_B1_sg13g2_mux2_1_X/S
+ VDD VSS bist_a\[4\]_sg13g2_dfrbpq_1_Q/Q sg13g2_mux2_1
Xuio_out_sg13g2_nand2_1_Y_3_A_sg13g2_a22oi_1_Y uio_out_sg13g2_nand2_1_Y_3/A bist_done_sg13g2_a22oi_1_B2/A2
+ VDD misr\[4\]_sg13g2_a22oi_1_B2/A2 cycle_counter\[1\]_sg13g2_dfrbpq_1_Q/Q VSS fault_counter\[1\]_sg13g2_dfrbpq_1_Q/Q
+ sg13g2_a22oi_1
Xserial_a\[2\]_sg13g2_dfrbpq_1_Q VDD serial_a\[2\]_sg13g2_dfrbpq_1_Q/D serial_b\[2\]_sg13g2_xor2_1_A/B
+ clkbuf_5_16__f_clk/X VSS rst_n sg13g2_dfrbpq_1
Xscan_reg\[49\]_sg13g2_o21ai_1_A1_B1_sg13g2_nand2b_1_Y VSS fault_counter\[7\]_sg13g2_dfrbpq_1_Q/Q
+ scan_reg\[49\]_sg13g2_o21ai_1_A1/B1 ui_in[3] VDD sg13g2_nand2b_1
Xlfsr\[3\]_sg13g2_dfrbpq_1_Q_D_sg13g2_inv_1_Y lfsr\[3\]_sg13g2_dfrbpq_1_Q/D lfsr\[2\]_sg13g2_a22oi_1_B2/Y
+ VSS VDD sg13g2_inv_1
Xoperation\[2\]_sg13g2_dfrbpq_1_Q_D_sg13g2_o21ai_1_Y VSS VDD operation\[2\]_sg13g2_dfrbpq_1_Q/D
+ operation\[2\]_sg13g2_dfrbpq_1_Q_D_sg13g2_o21ai_1_Y/B1 ui_in[2] operation\[2\]_sg13g2_inv_1_A/Y
+ sg13g2_o21ai_1
Xoperand_b\[1\]_sg13g2_dfrbpq_1_Q_D_sg13g2_o21ai_1_Y_B1_sg13g2_nand2_1_Y operand_b\[1\]_sg13g2_dfrbpq_1_Q_D_sg13g2_o21ai_1_Y/B1
+ VDD serial_b\[1\]_sg13g2_xor2_1_A/A VSS ui_in[2] sg13g2_nand2_1
Xoperand_b\[6\]_sg13g2_dfrbpq_1_Q VDD operand_b\[6\]_sg13g2_mux2_1_A0/X operand_b\[6\]_sg13g2_mux2_1_A0/A0
+ clkbuf_5_20__f_clk/X VSS rst_n sg13g2_dfrbpq_1
Xuo_out_sg13g2_dfrbpq_1_Q_6_D_sg13g2_a21oi_1_Y_B1_sg13g2_nor2_1_Y uo_out[4] VDD uo_out_sg13g2_dfrbpq_1_Q_6_D_sg13g2_a21oi_1_Y/B1
+ VSS ui_in[2] sg13g2_nor2_1
Xbist_a\[1\]_sg13g2_dfrbpq_1_Q VDD bist_a\[1\]_sg13g2_dfrbpq_1_Q/D bist_a\[1\]_sg13g2_dfrbpq_1_Q/Q
+ clkbuf_5_4__f_clk/X VSS rst_n sg13g2_dfrbpq_1
Xmisr\[1\]_sg13g2_inv_1_A_Y_sg13g2_xnor2_1_A misr\[1\]_sg13g2_inv_1_A_Y_sg13g2_xnor2_1_A/Y
+ misr\[1\]_sg13g2_inv_1_A_Y_sg13g2_xnor2_1_A/B VDD misr\[1\]_sg13g2_inv_1_A/Y VSS
+ sg13g2_xnor2_1
Xscan_reg\[18\]_sg13g2_inv_1_A scan_reg\[18\]_sg13g2_inv_1_A/Y scan_reg\[18\]_sg13g2_inv_1_A/A
+ VSS VDD sg13g2_inv_1
Xclkload2 clkload2/Y clkload2/A VSS VDD sg13g2_inv_1
Xbist_pattern_count\[5\]_sg13g2_dfrbpq_1_Q_D_sg13g2_nor2_1_Y_B_sg13g2_xnor2_1_Y bist_pattern_count\[5\]_sg13g2_dfrbpq_1_Q_D_sg13g2_nor2_1_Y/B
+ bist_pattern_count\[4\]_sg13g2_and2_1_A/X VDD bist_pattern_count\[6\]_sg13g2_nand3_1_C/B
+ VSS sg13g2_xnor2_1
Xscan_reg\[21\]_sg13g2_dfrbpq_1_Q VDD scan_reg\[21\]_sg13g2_dfrbpq_1_Q/D scan_reg\[21\]_sg13g2_nor2_1_A/A
+ clkbuf_5_31__f_clk/X VSS rst_n sg13g2_dfrbpq_1
Xuo_out_sg13g2_dfrbpq_1_Q_D_sg13g2_a21oi_1_Y_B1_sg13g2_a21oi_1_Y_A1_sg13g2_nand3_1_Y_B_sg13g2_a221oi_1_Y_B1_sg13g2_xnor2_1_Y_A_sg13g2_a21oi_1_Y_A2_sg13g2_o21ai_1_Y_A2_sg13g2_nor2b_1_Y
+ serial_b\[0\]_sg13g2_xnor2_1_B/A serial_b\[0\]_sg13g2_xnor2_1_B/B VDD uo_out_sg13g2_dfrbpq_1_Q_D_sg13g2_a21oi_1_Y_B1_sg13g2_a21oi_1_Y_A1_sg13g2_nand3_1_Y_B_sg13g2_a221oi_1_Y_B1_sg13g2_xnor2_1_Y_A_sg13g2_a21oi_1_Y_A2_sg13g2_o21ai_1_Y/A2
+ VSS sg13g2_nor2b_1
Xscan_reg\[17\]_sg13g2_o21ai_1_A1 VSS VDD scan_reg\[17\]_sg13g2_o21ai_1_A1/Y scan_reg\[17\]_sg13g2_o21ai_1_A1/B1
+ scan_reg\[3\]_sg13g2_nor2_1_A/B scan_reg\[17\]_sg13g2_dfrbpq_1_Q/Q sg13g2_o21ai_1
Xuo_out_sg13g2_dfrbpq_1_Q_4_D_sg13g2_a21oi_1_Y_A2_sg13g2_a21o_1_X_A2_sg13g2_a21o_1_X
+ uo_out_sg13g2_dfrbpq_1_Q_4_D_sg13g2_a21oi_1_Y_A2_sg13g2_a21o_1_X_A2_sg13g2_a21o_1_X/B1
+ uo_out_sg13g2_dfrbpq_1_Q_4_D_sg13g2_a21oi_1_Y_A2_sg13g2_a21o_1_X/A2 VDD VSS uo_out_sg13g2_dfrbpq_1_Q_4_D_sg13g2_a21oi_1_Y_A2_sg13g2_a21o_1_X_A2_sg13g2_a21o_1_X/A1
+ uo_out_sg13g2_dfrbpq_1_Q_4_D_sg13g2_a21oi_1_Y_A2_sg13g2_a21o_1_X_B1_sg13g2_and2_1_X/B
+ sg13g2_a21o_1
Xmisr\[1\]_sg13g2_dfrbpq_1_Q_D_sg13g2_a22oi_1_Y_B2_sg13g2_o21ai_1_Y_A2_sg13g2_a22oi_1_Y
+ misr\[1\]_sg13g2_dfrbpq_1_Q_D_sg13g2_a22oi_1_Y_B2_sg13g2_o21ai_1_Y/A2 misr\[1\]_sg13g2_dfrbpq_1_Q_D_sg13g2_a22oi_1_Y_B2_sg13g2_o21ai_1_Y_A2_sg13g2_a22oi_1_Y/A2
+ VDD misr\[1\]_sg13g2_dfrbpq_1_Q_D_sg13g2_a22oi_1_Y_B2_sg13g2_o21ai_1_Y_A2_sg13g2_a22oi_1_Y/B1
+ uo_out_sg13g2_dfrbpq_1_Q_2_D_sg13g2_o21ai_1_Y_B1_sg13g2_nand3_1_Y_B_sg13g2_nand2_1_Y/B
+ VSS misr\[1\]_sg13g2_dfrbpq_1_Q_D_sg13g2_a22oi_1_Y_B2_sg13g2_o21ai_1_Y_A2_sg13g2_a22oi_1_Y/B2
+ sg13g2_a22oi_1
Xscan_reg\[41\]_sg13g2_dfrbpq_1_Q VDD scan_reg\[41\]_sg13g2_dfrbpq_1_Q/D scan_reg\[41\]_sg13g2_nor2_1_A/A
+ clkload2/A VSS rst_n sg13g2_dfrbpq_1
Xmisr\[4\]_sg13g2_inv_1_A_Y_sg13g2_xnor2_1_A_B_sg13g2_o21ai_1_Y_B1_sg13g2_or2_1_X_B_sg13g2_nor2_1_Y_B_sg13g2_nand2b_1_Y
+ VSS uio_in[4] misr\[4\]_sg13g2_inv_1_A_Y_sg13g2_xnor2_1_A_B_sg13g2_o21ai_1_Y_B1_sg13g2_or2_1_X_B_sg13g2_nor2_1_Y/B
+ uio_in[3] VDD sg13g2_nand2b_1
Xcarry_flag_sg13g2_o21ai_1_A1_B1_sg13g2_nand2_1_Y_A_sg13g2_nand3_1_Y_B_sg13g2_nand3_1_C_Y_sg13g2_o21ai_1_B1_A1_sg13g2_nand2b_1_Y
+ VSS serial_opcode\[2\]_sg13g2_nand2_1_A/Y carry_flag_sg13g2_o21ai_1_A1_B1_sg13g2_nand2_1_Y_A_sg13g2_nand3_1_Y_B_sg13g2_nand3_1_C_Y_sg13g2_o21ai_1_B1/A1
+ serial_opcode\[1\]_sg13g2_nor2b_1_A/Y VDD sg13g2_nand2b_1
Xbist_a\[7\]_sg13g2_dfrbpq_1_Q_D_sg13g2_o21ai_1_Y_A1_sg13g2_nand2_1_A_Y_sg13g2_a221oi_1_B2_Y_sg13g2_o21ai_1_B1
+ VSS VDD misr\[3\]_sg13g2_dfrbpq_1_Q_D_sg13g2_o21ai_1_Y_A2_sg13g2_xnor2_1_Y_B_sg13g2_a22oi_1_Y_A2_sg13g2_a21oi_1_Y/B1
+ bist_a\[7\]_sg13g2_dfrbpq_1_Q_D_sg13g2_o21ai_1_Y_A1_sg13g2_nand2_1_A_Y_sg13g2_a221oi_1_B2/Y
+ bist_a\[7\]_sg13g2_dfrbpq_1_Q_D_sg13g2_o21ai_1_Y_A1_sg13g2_nand2_1_A_Y_sg13g2_a221oi_1_B2_Y_sg13g2_o21ai_1_B1/A2
+ bist_a\[7\]_sg13g2_dfrbpq_1_Q_D_sg13g2_o21ai_1_Y_A1_sg13g2_nand2_1_A_Y_sg13g2_a221oi_1_B2_Y_sg13g2_o21ai_1_B1/A1
+ sg13g2_o21ai_1
Xserial_b\[3\]_sg13g2_inv_1_A serial_b\[3\]_sg13g2_inv_1_A/Y serial_b\[3\]_sg13g2_inv_1_A/A
+ VSS VDD sg13g2_inv_1
Xscan_reg\[13\]_sg13g2_nor2_1_A scan_reg\[13\]_sg13g2_nor2_1_A/A VDD scan_reg\[13\]_sg13g2_nor2_1_A/Y
+ VSS scan_reg\[3\]_sg13g2_nor2_1_A/B sg13g2_nor2_1
Xbist_a\[7\]_sg13g2_dfrbpq_1_Q_D_sg13g2_o21ai_1_Y_A1_sg13g2_o21ai_1_A1_B1_sg13g2_nand4_1_C_Y_sg13g2_a221oi_1_C1_B1_sg13g2_nor2_1_Y_A_sg13g2_and3_1_X
+ bist_a\[7\]_sg13g2_dfrbpq_1_Q_D_sg13g2_o21ai_1_Y_A1_sg13g2_o21ai_1_A1_B1_sg13g2_nand4_1_C_Y_sg13g2_a221oi_1_C1_B1_sg13g2_nor2_1_Y/A
+ bist_a\[7\]_sg13g2_dfrbpq_1_Q_D_sg13g2_o21ai_1_Y_A1_sg13g2_o21ai_1_A1_Y_sg13g2_nand2b_1_A_N_B_sg13g2_a21oi_1_Y/A1
+ VDD VSS bist_a\[7\]_sg13g2_dfrbpq_1_Q_D_sg13g2_o21ai_1_Y_A1_sg13g2_o21ai_1_A1_B1_sg13g2_nand4_1_C_Y_sg13g2_a221oi_1_C1_B1_sg13g2_nor2_1_Y_A_sg13g2_and3_1_X/C
+ bist_a\[7\]_sg13g2_or2_1_A/X sg13g2_and3_1
Xbist_pattern_count\[3\]_sg13g2_nor2_1_A bist_pattern_count\[3\]_sg13g2_nor2_1_A/A
+ VDD bist_pattern_count\[3\]_sg13g2_nor2_1_A/Y VSS bist_pattern_count\[3\]_sg13g2_nor2_1_A/B
+ sg13g2_nor2_1
Xmisr\[6\]_sg13g2_dfrbpq_1_Q_D_sg13g2_o21ai_1_Y_A2_sg13g2_xnor2_1_Y_B_sg13g2_a22oi_1_Y_A1_sg13g2_and4_1_X_A_sg13g2_nand2_1_Y_B_sg13g2_xnor2_1_Y
+ misr\[6\]_sg13g2_dfrbpq_1_Q_D_sg13g2_o21ai_1_Y_A2_sg13g2_xnor2_1_Y_B_sg13g2_a22oi_1_Y_A1_sg13g2_and4_1_X_A_sg13g2_nand2_1_Y/B
+ misr\[6\]_sg13g2_dfrbpq_1_Q_D_sg13g2_o21ai_1_Y_A2_sg13g2_xnor2_1_Y_B_sg13g2_a22oi_1_Y_A1_sg13g2_and4_1_X_A_sg13g2_nand2_1_Y_B_sg13g2_xnor2_1_Y/B
+ VDD misr\[1\]_sg13g2_inv_1_A_Y_sg13g2_xnor2_1_A_B_sg13g2_o21ai_1_Y_A2_sg13g2_nand3_1_Y_C_sg13g2_a22oi_1_Y_B1_sg13g2_and2_1_X_A_sg13g2_or3_1_X/A
+ VSS sg13g2_xnor2_1
Xoverflow_flag_sg13g2_dfrbpq_1_Q_D_sg13g2_inv_1_Y_A_sg13g2_o21ai_1_Y_B1_sg13g2_nand3_1_Y_A_sg13g2_nand2_1_Y_B_sg13g2_a21oi_1_Y_A2_sg13g2_o21ai_1_Y_A1_sg13g2_and2_1_X
+ overflow_flag_sg13g2_dfrbpq_1_Q_D_sg13g2_inv_1_Y_A_sg13g2_o21ai_1_Y_B1_sg13g2_nand3_1_Y_A_sg13g2_nand2_1_Y_B_sg13g2_a21oi_1_Y_A2_sg13g2_o21ai_1_Y/A1
+ VSS VDD serial_a\[5\]_sg13g2_dfrbpq_1_Q/Q serial_b\[5\]_sg13g2_nand2b_1_B/B sg13g2_and2_1
Xserial_b\[5\]_sg13g2_dfrbpq_1_Q VDD serial_b\[5\]_sg13g2_dfrbpq_1_Q/D serial_b\[5\]_sg13g2_nand2b_1_B/B
+ clkbuf_5_20__f_clk/X VSS rst_n sg13g2_dfrbpq_1
Xbist_a\[7\]_sg13g2_dfrbpq_1_Q_D_sg13g2_o21ai_1_Y_A1_sg13g2_o21ai_1_A1_Y_sg13g2_nand2b_1_A_N_B_sg13g2_a21oi_1_Y_B1_sg13g2_a21oi_1_Y_A2_sg13g2_a21oi_1_A2
+ VDD VSS bist_a\[7\]_sg13g2_dfrbpq_1_Q_D_sg13g2_o21ai_1_Y_A1_sg13g2_o21ai_1_A1_Y_sg13g2_nand2b_1_A_N_B_sg13g2_a21oi_1_Y_B1_sg13g2_a21oi_1_Y/A2
+ bist_a\[7\]_sg13g2_dfrbpq_1_Q_D_sg13g2_o21ai_1_Y_A1_sg13g2_nand2_1_A_B_sg13g2_inv_1_Y_A_sg13g2_nor2_1_Y/B
+ bist_a\[7\]_sg13g2_dfrbpq_1_Q_D_sg13g2_o21ai_1_Y_A1_sg13g2_o21ai_1_A1_A2_sg13g2_nand3_1_Y/C
+ misr\[3\]_sg13g2_dfrbpq_1_Q_D_sg13g2_o21ai_1_Y_A2_sg13g2_xnor2_1_Y_B_sg13g2_a22oi_1_Y_A2_sg13g2_a21oi_1_Y/A2
+ sg13g2_a21oi_1
Xuo_out_sg13g2_dfrbpq_1_Q_D_sg13g2_a21oi_1_Y_B1_sg13g2_a21oi_1_Y_A1_sg13g2_nand3_1_Y_A_sg13g2_nand2_1_Y
+ uo_out_sg13g2_dfrbpq_1_Q_D_sg13g2_a21oi_1_Y_B1_sg13g2_a21oi_1_Y_A1_sg13g2_nand3_1_Y/A
+ VDD serial_a\[3\]_sg13g2_dfrbpq_1_Q/Q VSS uo_out_sg13g2_dfrbpq_1_Q_D_sg13g2_a21oi_1_Y_B1_sg13g2_a21oi_1_Y_A1_sg13g2_nand3_1_Y_A_sg13g2_nand2_1_Y/B
+ sg13g2_nand2_1
Xcarry_flag_sg13g2_o21ai_1_A1_B1_sg13g2_nand2_1_Y_B_sg13g2_a21oi_1_Y_A1_sg13g2_and2_1_X
+ carry_flag_sg13g2_o21ai_1_A1_B1_sg13g2_nand2_1_Y_B_sg13g2_a21oi_1_Y/A1 VSS VDD serial_opcode\[2\]_sg13g2_nor2_1_A/Y
+ serial_opcode\[1\]_sg13g2_nor2_1_A/Y sg13g2_and2_1
Xcarry_flag_sg13g2_o21ai_1_A1_B1_sg13g2_nand2_1_Y_A_sg13g2_nand3_1_Y_B_sg13g2_nand3_1_C_A_sg13g2_o21ai_1_B1_Y_sg13g2_o21ai_1_B1
+ VSS VDD uo_out_sg13g2_dfrbpq_1_Q_D_sg13g2_a21oi_1_Y_B1_sg13g2_a21oi_1_Y_A1_sg13g2_nand3_1_Y_A_sg13g2_nand2_1_Y/B
+ carry_flag_sg13g2_o21ai_1_A1_B1_sg13g2_nand2_1_Y_A_sg13g2_nand3_1_Y_B_sg13g2_nand3_1_C_A_sg13g2_o21ai_1_B1/Y
+ carry_flag_sg13g2_o21ai_1_A1_B1_sg13g2_nand2_1_Y_A_sg13g2_nand3_1_Y_B_sg13g2_nand3_1_C_A_sg13g2_o21ai_1_B1_Y_sg13g2_o21ai_1_B1/A2
+ carry_flag_sg13g2_o21ai_1_A1_B1_sg13g2_nand2_1_Y_A_sg13g2_nand3_1_Y_B_sg13g2_nand3_1_C_Y_sg13g2_o21ai_1_B1/A1
+ sg13g2_o21ai_1
Xbist_pattern_count\[0\]_sg13g2_dfrbpq_1_Q VDD bist_pattern_count\[0\]_sg13g2_dfrbpq_1_Q/D
+ bist_pattern_count\[1\]_sg13g2_and3_1_A/B clkbuf_5_6__f_clk/X VSS rst_n sg13g2_dfrbpq_1
Xmisr\[4\]_sg13g2_inv_1_A_Y_sg13g2_xnor2_1_A_B_sg13g2_o21ai_1_Y_A1_sg13g2_a21oi_1_Y_B1_sg13g2_inv_1_Y
+ misr\[4\]_sg13g2_inv_1_A_Y_sg13g2_xnor2_1_A_B_sg13g2_o21ai_1_Y_A1_sg13g2_a21oi_1_Y/B1
+ uio_in[1] VSS VDD sg13g2_inv_1
Xmisr\[1\]_sg13g2_dfrbpq_1_Q_D_sg13g2_a22oi_1_Y_B2_sg13g2_o21ai_1_Y_B1_sg13g2_a21oi_1_Y
+ VDD VSS misr\[1\]_sg13g2_dfrbpq_1_Q_D_sg13g2_a22oi_1_Y_B2_sg13g2_o21ai_1_Y/A2 misr\[0\]_sg13g2_dfrbpq_1_Q/Q
+ bist_state\[1\]_sg13g2_inv_1_A/Y misr\[1\]_sg13g2_dfrbpq_1_Q_D_sg13g2_a22oi_1_Y_B2_sg13g2_o21ai_1_Y/B1
+ sg13g2_a21oi_1
Xuo_out_sg13g2_dfrbpq_1_Q_1_D_sg13g2_a21oi_1_Y_B1_sg13g2_nor2_1_Y uo_out[2] VDD uo_out_sg13g2_dfrbpq_1_Q_1_D_sg13g2_a21oi_1_Y/B1
+ VSS ui_in[2] sg13g2_nor2_1
Xmisr\[3\]_sg13g2_dfrbpq_1_Q_D_sg13g2_o21ai_1_Y_A2_sg13g2_xnor2_1_Y_B_sg13g2_a22oi_1_Y_A2_sg13g2_a21oi_1_Y
+ VDD VSS misr\[3\]_sg13g2_dfrbpq_1_Q_D_sg13g2_o21ai_1_Y_A2_sg13g2_xnor2_1_Y_B_sg13g2_a22oi_1_Y_A2_sg13g2_a21oi_1_Y/A2
+ bist_a\[4\]_sg13g2_dfrbpq_1_Q/Q misr\[3\]_sg13g2_dfrbpq_1_Q_D_sg13g2_o21ai_1_Y_A2_sg13g2_xnor2_1_Y_B_sg13g2_a22oi_1_Y_A2_sg13g2_a21oi_1_Y/B1
+ misr\[3\]_sg13g2_dfrbpq_1_Q_D_sg13g2_o21ai_1_Y_A2_sg13g2_xnor2_1_Y_B_sg13g2_a22oi_1_Y/A2
+ sg13g2_a21oi_1
Xuo_out_sg13g2_dfrbpq_1_Q_D_sg13g2_a21oi_1_Y_B1_sg13g2_a21oi_1_Y_A1_sg13g2_nand3_1_Y_B_sg13g2_a221oi_1_Y_C1_sg13g2_o21ai_1_Y_A1_sg13g2_nor2_1_B
+ carry_flag_sg13g2_o21ai_1_A1_B1_sg13g2_nand2_1_Y_B_sg13g2_a21oi_1_Y_A2_sg13g2_a21oi_1_Y_B1_sg13g2_o21ai_1_B1/A2
+ VDD uo_out_sg13g2_dfrbpq_1_Q_D_sg13g2_a21oi_1_Y_B1_sg13g2_a21oi_1_Y_A1_sg13g2_nand3_1_Y_B_sg13g2_a221oi_1_Y_C1_sg13g2_o21ai_1_Y_A1_sg13g2_nor2_1_B/Y
+ VSS uo_out_sg13g2_dfrbpq_1_Q_D_sg13g2_a21oi_1_Y_B1_sg13g2_a21oi_1_Y_A1_sg13g2_nand3_1_Y_B_sg13g2_a221oi_1_Y_C1_sg13g2_o21ai_1_Y/A1
+ sg13g2_nor2_1
Xclkbuf_5_18__f_clk clkbuf_5_18__f_clk/X VSS clkbuf_4_9_0_clk/X VDD sg13g2_buf_4
Xfault_counter\[6\]_sg13g2_dfrbpq_1_Q_D_sg13g2_xnor2_1_Y fault_counter\[6\]_sg13g2_dfrbpq_1_Q/D
+ fault_counter\[5\]_sg13g2_dfrbpq_1_Q_D_sg13g2_and2_1_X/A VDD scan_out_sg13g2_a22oi_1_A1_1/B2
+ VSS sg13g2_xnor2_1
Xmisr\[1\]_sg13g2_inv_1_A_Y_sg13g2_xnor2_1_A_B_sg13g2_o21ai_1_Y_A2_sg13g2_nand3_1_Y_B_sg13g2_nor3_1_Y_B_sg13g2_a21oi_1_B1_A2_sg13g2_nor2b_1_Y_A_sg13g2_nor3_1_Y
+ misr\[1\]_sg13g2_inv_1_A_Y_sg13g2_xnor2_1_A_B_sg13g2_o21ai_1_Y_A2_sg13g2_nand3_1_Y_C_sg13g2_a22oi_1_Y_B1_sg13g2_and2_1_X_A_sg13g2_or3_1_X/A
+ misr\[1\]_sg13g2_inv_1_A_Y_sg13g2_xnor2_1_A_B_sg13g2_o21ai_1_Y_A2_sg13g2_nand3_1_Y_B_sg13g2_nor3_1_Y_B_sg13g2_a21oi_1_B1_A2_sg13g2_nor2b_1_Y/A
+ misr\[1\]_sg13g2_inv_1_A_Y_sg13g2_xnor2_1_A_B_sg13g2_o21ai_1_Y_A2_sg13g2_nand3_1_Y_C_sg13g2_a22oi_1_Y_B1_sg13g2_and2_1_X_A_sg13g2_or3_1_X/B
+ misr\[1\]_sg13g2_inv_1_A_Y_sg13g2_xnor2_1_A_B_sg13g2_o21ai_1_Y_A2_sg13g2_nand3_1_Y_B_sg13g2_nor3_1_Y_B_sg13g2_a21oi_1_B1_A1_sg13g2_o21ai_1_Y/A2
+ VDD VSS sg13g2_nor3_1
Xscan_reg\[38\]_sg13g2_a22oi_1_B1 scan_reg\[38\]_sg13g2_a22oi_1_B1/Y ui_in[3] VDD
+ scan_reg\[38\]_sg13g2_inv_1_A/A misr\[5\]_sg13g2_dfrbpq_1_Q/Q VSS scan_out_sg13g2_a22oi_1_A1/B1
+ sg13g2_a22oi_1
Xmisr\[2\]_sg13g2_dfrbpq_1_Q VDD misr\[2\]_sg13g2_dfrbpq_1_Q/D misr\[2\]_sg13g2_dfrbpq_1_Q/Q
+ clkbuf_5_18__f_clk/X VSS rst_n sg13g2_dfrbpq_1
Xclkload3 clkload3/Y clkload3/A VSS VDD sg13g2_inv_1
Xmisr\[4\]_sg13g2_inv_1_A_Y_sg13g2_xnor2_1_A_B_sg13g2_o21ai_1_Y_B1_sg13g2_or2_1_X_A_sg13g2_nand3_1_Y_B_sg13g2_a22oi_1_Y_B1_sg13g2_o21ai_1_Y_B1_sg13g2_nand2_1_Y
+ misr\[4\]_sg13g2_inv_1_A_Y_sg13g2_xnor2_1_A_B_sg13g2_o21ai_1_Y_B1_sg13g2_or2_1_X_A_sg13g2_nand3_1_Y_B_sg13g2_a22oi_1_Y_B1_sg13g2_o21ai_1_Y/B1
+ VDD bist_a\[5\]_sg13g2_dfrbpq_1_Q/Q VSS bist_a\[7\]_sg13g2_dfrbpq_1_Q_D_sg13g2_o21ai_1_Y_A1_sg13g2_o21ai_1_A1_Y_sg13g2_nand2b_1_A_N_Y_sg13g2_a221oi_1_C1_B1_sg13g2_mux2_1_X/S
+ sg13g2_nand2_1
Xmisr\[1\]_sg13g2_inv_1_A_Y_sg13g2_xnor2_1_A_B_sg13g2_o21ai_1_Y_A2_sg13g2_nand3_1_Y_B_sg13g2_nor3_1_Y_B_sg13g2_a21oi_1_B1
+ VDD VSS misr\[1\]_sg13g2_inv_1_A_Y_sg13g2_xnor2_1_A_B_sg13g2_o21ai_1_Y_A2_sg13g2_nand3_1_Y_B_sg13g2_nor3_1_Y_B_sg13g2_a21oi_1_B1/A2
+ misr\[1\]_sg13g2_inv_1_A_Y_sg13g2_xnor2_1_A_B_sg13g2_o21ai_1_Y_A2_sg13g2_nand3_1_Y_B_sg13g2_nor3_1_Y_B_sg13g2_a21oi_1_B1/A1
+ misr\[1\]_sg13g2_inv_1_A_Y_sg13g2_xnor2_1_A_B_sg13g2_o21ai_1_Y_A2_sg13g2_nand3_1_Y_B_sg13g2_nor3_1_Y/B
+ misr\[6\]_sg13g2_dfrbpq_1_Q_D_sg13g2_o21ai_1_Y_A2_sg13g2_xnor2_1_Y_B_sg13g2_a22oi_1_Y_A1_sg13g2_and4_1_X/C
+ sg13g2_a21oi_1
Xscan_reg\[57\]_sg13g2_dfrbpq_1_Q_D_sg13g2_a21oi_1_Y_A2_sg13g2_nand2_1_Y scan_reg\[57\]_sg13g2_dfrbpq_1_Q_D_sg13g2_a21oi_1_Y/A2
+ VDD cycle_counter\[7\]_sg13g2_dfrbpq_1_Q/Q VSS ui_in[3] sg13g2_nand2_1
Xbist_a\[7\]_sg13g2_dfrbpq_1_Q_D_sg13g2_o21ai_1_Y_A1_sg13g2_o21ai_1_A1_B1_sg13g2_nand4_1_C_Y_sg13g2_a221oi_1_C1_B1_sg13g2_nor2_1_Y
+ bist_a\[7\]_sg13g2_dfrbpq_1_Q_D_sg13g2_o21ai_1_Y_A1_sg13g2_o21ai_1_A1_B1_sg13g2_nand4_1_C_Y_sg13g2_a221oi_1_C1_B1_sg13g2_nor2_1_Y/A
+ VDD bist_a\[7\]_sg13g2_dfrbpq_1_Q_D_sg13g2_o21ai_1_Y_A1_sg13g2_o21ai_1_A1_B1_sg13g2_nand4_1_C_Y_sg13g2_a221oi_1_C1/B1
+ VSS bist_a\[7\]_sg13g2_dfrbpq_1_Q_D_sg13g2_o21ai_1_Y_A1_sg13g2_o21ai_1_A1_B1_sg13g2_nand4_1_C_Y_sg13g2_a221oi_1_C1_B1_sg13g2_nor2_1_Y/B
+ sg13g2_nor2_1
Xlfsr\[1\]_sg13g2_dfrbpq_1_Q VDD lfsr\[1\]_sg13g2_dfrbpq_1_Q/D lfsr\[1\]_sg13g2_nand2_1_A/A
+ clkbuf_5_3__f_clk/X VSS rst_n sg13g2_dfrbpq_1
Xcarry_flag_sg13g2_o21ai_1_A1_B1_sg13g2_nand2_1_Y_B_sg13g2_a21oi_1_Y_A2_sg13g2_a21oi_1_Y_B1_sg13g2_o21ai_1_B1_Y_sg13g2_a221oi_1_B1_1_B2_sg13g2_xnor2_1_Y_B_sg13g2_o21ai_1_Y_A1_sg13g2_nand2b_1_A_N_Y_sg13g2_nand4_1_C_D_sg13g2_or2_1_X
+ serial_b\[1\]_sg13g2_xor2_1_A/B VSS overflow_flag_sg13g2_dfrbpq_1_Q_D_sg13g2_inv_1_Y_A_sg13g2_o21ai_1_Y_B1_sg13g2_nand3_1_Y_A_sg13g2_and4_1_A_B_sg13g2_or2_1_X/B
+ carry_flag_sg13g2_o21ai_1_A1_B1_sg13g2_nand2_1_Y_B_sg13g2_a21oi_1_Y_A2_sg13g2_a21oi_1_Y_B1_sg13g2_o21ai_1_B1_Y_sg13g2_a221oi_1_B1_1_B2_sg13g2_xnor2_1_Y_B_sg13g2_o21ai_1_Y_A1_sg13g2_nand2b_1_A_N_Y_sg13g2_nand4_1_C/D
+ VDD sg13g2_or2_1
Xlfsr\[2\]_sg13g2_dfrbpq_1_Q_D_sg13g2_inv_1_Y lfsr\[2\]_sg13g2_dfrbpq_1_Q/D lfsr\[2\]_sg13g2_a22oi_1_A1/Y
+ VSS VDD sg13g2_inv_1
Xmisr\[0\]_sg13g2_dfrbpq_1_Q_D_sg13g2_a22oi_1_Y_B2_sg13g2_o21ai_1_Y_A2_sg13g2_a21oi_1_Y_A2_sg13g2_nor2b_1_Y_A_sg13g2_nor4_1_Y
+ VSS VDD bist_a\[3\]_sg13g2_dfrbpq_1_Q_D_sg13g2_o21ai_1_Y/A1 misr\[0\]_sg13g2_dfrbpq_1_Q_D_sg13g2_a22oi_1_Y_B2_sg13g2_o21ai_1_Y_A2_sg13g2_a21oi_1_Y_A2_sg13g2_nor2b_1_Y_A_sg13g2_nor4_1_Y/C
+ misr\[0\]_sg13g2_dfrbpq_1_Q_D_sg13g2_a22oi_1_Y_B2_sg13g2_o21ai_1_Y_A2_sg13g2_a21oi_1_Y_A2_sg13g2_nor2b_1_Y/A
+ bist_a\[2\]_sg13g2_dfrbpq_1_Q/Q bist_a\[7\]_sg13g2_dfrbpq_1_Q_D_sg13g2_o21ai_1_Y_A1_sg13g2_o21ai_1_A1_B1_sg13g2_a21oi_1_Y_B1_sg13g2_nor3_1_Y/C
+ sg13g2_nor4_1
Xbist_fault_sg13g2_nor2_1_B_Y_sg13g2_o21ai_1_A2_B1_sg13g2_nand3b_1_Y_B_sg13g2_nand2_1_B
+ bist_fault_sg13g2_nor2_1_B_Y_sg13g2_o21ai_1_A2_B1_sg13g2_nand3b_1_Y_B_sg13g2_nand2_1_B/Y
+ VDD lfsr\[7\]_sg13g2_a22oi_1_A1/A2 VSS bist_fault_sg13g2_nor2_1_B_Y_sg13g2_o21ai_1_A2_B1_sg13g2_nand3b_1_Y/B
+ sg13g2_nand2_1
Xbist_pattern_count\[6\]_sg13g2_nand3_1_C_Y_sg13g2_nor3_1_C_Y_sg13g2_a21oi_1_A2 VDD
+ VSS bist_pattern_count\[6\]_sg13g2_nand3_1_C_Y_sg13g2_nor3_1_C/Y bist_state\[1\]_sg13g2_inv_1_A/A
+ lfsr\[7\]_sg13g2_a22oi_1_A1/A2 bist_pattern_count\[1\]_sg13g2_and3_1_A/C sg13g2_a21oi_1
Xoperation\[3\]_sg13g2_dfrbpq_1_Q_D_sg13g2_a21oi_1_Y_A1_sg13g2_a21oi_1_A1_Y_sg13g2_nor2_1_B_Y_sg13g2_a21oi_1_B1_Y_sg13g2_nand3_1_A_B_sg13g2_nand2b_1_Y_A_N_sg13g2_nand2_1_Y
+ operation\[3\]_sg13g2_dfrbpq_1_Q_D_sg13g2_a21oi_1_Y_A1_sg13g2_a21oi_1_A1_Y_sg13g2_nor2_1_B_Y_sg13g2_a21oi_1_B1_Y_sg13g2_nand3_1_A_B_sg13g2_nand2b_1_Y/A_N
+ VDD serial_b\[0\]_sg13g2_xnor2_1_B/A VSS serial_b\[0\]_sg13g2_xnor2_1_B/B sg13g2_nand2_1
Xscan_reg\[14\]_sg13g2_dfrbpq_1_Q VDD scan_reg\[14\]_sg13g2_dfrbpq_1_Q/D scan_reg\[14\]_sg13g2_inv_1_A/A
+ clkbuf_5_23__f_clk/X VSS rst_n sg13g2_dfrbpq_1
Xclkbuf_0_clk clkbuf_0_clk/X VSS clk VDD sg13g2_buf_4
Xserial_b\[1\]_sg13g2_dfrbpq_1_Q_D_sg13g2_o21ai_1_Y_A1_sg13g2_inv_1_Y serial_b\[1\]_sg13g2_dfrbpq_1_Q_D_sg13g2_o21ai_1_Y/A1
+ serial_b\[1\]_sg13g2_xor2_1_A/A VSS VDD sg13g2_inv_1
Xscan_reg\[34\]_sg13g2_dfrbpq_1_Q VDD scan_reg\[34\]_sg13g2_dfrbpq_1_Q/D scan_reg\[34\]_sg13g2_inv_1_A/A
+ clkbuf_5_24__f_clk/X VSS rst_n sg13g2_dfrbpq_1
Xscan_reg\[22\]_sg13g2_dfrbpq_1_Q_D_sg13g2_a221oi_1_Y scan_reg\[23\]_sg13g2_nor2_1_A/Y
+ scan_reg\[22\]_sg13g2_dfrbpq_1_Q/D scan_out_sg13g2_a22oi_1_A1/A2 scan_reg\[22\]_sg13g2_inv_1_A/Y
+ scan_reg\[22\]_sg13g2_dfrbpq_1_Q_D_sg13g2_a221oi_1_Y/A2 VDD ui_in[3] VSS sg13g2_a221oi_1
Xlfsr\[2\]_sg13g2_nand2_1_A lfsr\[2\]_sg13g2_nand2_1_A/Y VDD lfsr\[2\]_sg13g2_nand2_1_A/A
+ VSS lfsr\[7\]_sg13g2_nand2_1_A/B sg13g2_nand2_1
Xscan_reg\[54\]_sg13g2_dfrbpq_1_Q VDD scan_reg\[54\]_sg13g2_dfrbpq_1_Q/D scan_reg\[54\]_sg13g2_inv_1_A/A
+ clkbuf_5_15__f_clk/X VSS rst_n sg13g2_dfrbpq_1
Xmisr\[4\]_sg13g2_inv_1_A_Y_sg13g2_xnor2_1_A_B_sg13g2_o21ai_1_Y_B1_sg13g2_or2_1_X_A_sg13g2_nand3_1_Y_C_sg13g2_a21oi_1_Y_B1_sg13g2_a221oi_1_Y
+ bist_a\[7\]_sg13g2_dfrbpq_1_Q_D_sg13g2_o21ai_1_Y_A1_sg13g2_nand2_1_A_Y_sg13g2_a221oi_1_A1_Y_sg13g2_o21ai_1_B1/A2
+ misr\[4\]_sg13g2_inv_1_A_Y_sg13g2_xnor2_1_A_B_sg13g2_o21ai_1_Y_B1_sg13g2_or2_1_X_A_sg13g2_nand3_1_Y_C_sg13g2_a21oi_1_Y/B1
+ misr\[4\]_sg13g2_inv_1_A_Y_sg13g2_xnor2_1_A_B_sg13g2_o21ai_1_Y_B1_sg13g2_or2_1_X_A_sg13g2_nand3_1_Y_C_sg13g2_a21oi_1_Y_B1_sg13g2_a221oi_1_Y/B2
+ misr\[4\]_sg13g2_inv_1_A_Y_sg13g2_xnor2_1_A_B_sg13g2_o21ai_1_Y_B1_sg13g2_or2_1_X_A_sg13g2_nand3_1_Y_C_sg13g2_a21oi_1_Y_B1_sg13g2_a221oi_1_Y/B1
+ misr\[4\]_sg13g2_inv_1_A_Y_sg13g2_xnor2_1_A_B_sg13g2_o21ai_1_Y_B1_sg13g2_or2_1_X_A_sg13g2_nand3_1_Y_C_sg13g2_a21oi_1_Y_B1_sg13g2_a221oi_1_Y/A2
+ VDD bist_a\[7\]_sg13g2_dfrbpq_1_Q_D_sg13g2_o21ai_1_Y_A1_sg13g2_o21ai_1_A1_Y_sg13g2_nand2b_1_A_N_Y_sg13g2_a221oi_1_C1_B1_sg13g2_mux2_1_X/S
+ VSS sg13g2_a221oi_1
Xbist_a\[1\]_sg13g2_dfrbpq_1_Q_D_sg13g2_o21ai_1_Y VSS VDD bist_a\[1\]_sg13g2_dfrbpq_1_Q/D
+ lfsr\[1\]_sg13g2_nand2_1_A/Y lfsr\[7\]_sg13g2_nand2_1_A/B bist_a\[1\]_sg13g2_dfrbpq_1_Q_D_sg13g2_o21ai_1_Y/A1
+ sg13g2_o21ai_1
Xuo_out_sg13g2_dfrbpq_1_Q_6_D_sg13g2_a21oi_1_Y_A2_sg13g2_a21o_1_X_B1_sg13g2_a221oi_1_Y_A2_sg13g2_nand2_1_Y
+ uo_out_sg13g2_dfrbpq_1_Q_6_D_sg13g2_a21oi_1_Y_A2_sg13g2_a21o_1_X_B1_sg13g2_a221oi_1_Y/A2
+ VDD uo_out_sg13g2_dfrbpq_1_Q_D_sg13g2_a21oi_1_Y_B1_sg13g2_a21oi_1_Y_A1_sg13g2_nand3_1_Y/A
+ VSS uo_out_sg13g2_dfrbpq_1_Q_D_sg13g2_a21oi_1_Y_B1_sg13g2_a21oi_1_Y_A1_sg13g2_nand3_1_Y/B
+ sg13g2_nand2_1
Xmisr\[4\]_sg13g2_inv_1_A_Y_sg13g2_xnor2_1_A_B_sg13g2_o21ai_1_Y_B1_sg13g2_or2_1_X_A_sg13g2_nand3_1_Y_B_sg13g2_a22oi_1_Y_A2_sg13g2_a21oi_1_Y_B1_sg13g2_nor2_1_Y
+ bist_a\[5\]_sg13g2_dfrbpq_1_Q/Q VDD misr\[4\]_sg13g2_inv_1_A_Y_sg13g2_xnor2_1_A_B_sg13g2_o21ai_1_Y_B1_sg13g2_or2_1_X_A_sg13g2_nand3_1_Y_B_sg13g2_a22oi_1_Y_A2_sg13g2_a21oi_1_Y/B1
+ VSS bist_a\[7\]_sg13g2_dfrbpq_1_Q_D_sg13g2_o21ai_1_Y_A1_sg13g2_o21ai_1_A1_Y_sg13g2_nand2b_1_A_N_Y_sg13g2_a221oi_1_C1_B1_sg13g2_mux2_1_X/S
+ sg13g2_nor2_1
Xclkbuf_5_24__f_clk clkbuf_5_24__f_clk/X VSS clkbuf_4_12_0_clk/X VDD sg13g2_buf_4
Xmisr\[1\]_sg13g2_inv_1_A_Y_sg13g2_xnor2_1_A_B_sg13g2_o21ai_1_Y_A2_sg13g2_nand3_1_Y_A_sg13g2_nand4_1_Y
+ VDD misr\[1\]_sg13g2_inv_1_A_Y_sg13g2_xnor2_1_A_B_sg13g2_o21ai_1_Y_A2_sg13g2_nand3_1_Y/A
+ lfsr\[6\]_sg13g2_mux2_1_A1/A0 bist_a\[7\]_sg13g2_or2_1_A/B VSS bist_a\[2\]_sg13g2_dfrbpq_1_Q/Q
+ bist_a\[7\]_sg13g2_dfrbpq_1_Q_D_sg13g2_o21ai_1_Y_A1_sg13g2_o21ai_1_A1_A2_sg13g2_nand3_1_Y/C
+ sg13g2_nand4_1
Xcycle_counter\[5\]_sg13g2_dfrbpq_1_Q_D_sg13g2_and2_1_X_B_sg13g2_a21o_1_X cycle_counter\[5\]_sg13g2_dfrbpq_1_Q/Q
+ cycle_counter\[5\]_sg13g2_dfrbpq_1_Q_D_sg13g2_and2_1_X/B VDD VSS bist_done_sg13g2_a22oi_1_B2/A1
+ cycle_counter\[4\]_sg13g2_dfrbpq_1_Q_D_sg13g2_xnor2_1_Y/B sg13g2_a21o_1
Xclkload4 clkload4/Y clkload4/A VSS VDD sg13g2_inv_1
Xscan_reg\[6\]_sg13g2_dfrbpq_1_Q VDD scan_reg\[6\]_sg13g2_dfrbpq_1_Q/D scan_reg\[6\]_sg13g2_dfrbpq_1_Q/Q
+ clkbuf_5_23__f_clk/X VSS rst_n sg13g2_dfrbpq_1
Xscan_reg\[2\]_sg13g2_dfrbpq_1_Q_D_sg13g2_a221oi_1_Y scan_reg\[3\]_sg13g2_nor2_1_A/Y
+ scan_reg\[2\]_sg13g2_dfrbpq_1_Q/D scan_out_sg13g2_a22oi_1_A1/A2 scan_reg\[2\]_sg13g2_inv_1_A/Y
+ operand_a\[2\]_sg13g2_inv_1_A/Y VDD ui_in[3] VSS sg13g2_a221oi_1
Xbist_fault_sg13g2_nor2_1_B_Y_sg13g2_o21ai_1_A2_B1_sg13g2_nand3b_1_Y bist_state\[1\]_sg13g2_a21oi_1_A1/B1
+ bist_fault_sg13g2_nor2_1_B_Y_sg13g2_o21ai_1_A2/B1 VDD VSS bist_fault_sg13g2_nor2_1_B_Y_sg13g2_o21ai_1_A2_B1_sg13g2_nand3b_1_Y/B
+ scan_reg\[41\]_sg13g2_dfrbpq_1_Q_D_sg13g2_a221oi_1_Y/A1 sg13g2_nand3b_1
Xoperand_a\[5\]_sg13g2_mux2_1_A0 serial_a\[5\]_sg13g2_dfrbpq_1_Q/Q operand_a\[5\]_sg13g2_mux2_1_A0/X
+ ui_in[2] VDD VSS operand_a\[5\]_sg13g2_mux2_1_A0/A0 sg13g2_mux2_1
Xuo_out_sg13g2_dfrbpq_1_Q_4_D_sg13g2_a21oi_1_Y_A2_sg13g2_a21o_1_X_B1_sg13g2_and2_1_X
+ uo_out_sg13g2_dfrbpq_1_Q_4_D_sg13g2_a21oi_1_Y_A2_sg13g2_a21o_1_X/B1 VSS VDD uo_out_sg13g2_dfrbpq_1_Q_4_D_sg13g2_a21oi_1_Y_A2_sg13g2_a21o_1_X_B1_sg13g2_and2_1_X/B
+ uo_out_sg13g2_dfrbpq_1_Q_4_D_sg13g2_a21oi_1_Y_A2_sg13g2_a21o_1_X_B1_sg13g2_and2_1_X/A
+ sg13g2_and2_1
Xoperation\[3\]_sg13g2_dfrbpq_1_Q_D_sg13g2_a21oi_1_Y_A1_sg13g2_a21oi_1_A1_Y_sg13g2_nor2_1_B_Y_sg13g2_a21oi_1_B1_Y_sg13g2_nand3_1_A_Y_sg13g2_nor2_1_B
+ operation\[3\]_sg13g2_dfrbpq_1_Q_D_sg13g2_a21oi_1_Y_A1_sg13g2_a21oi_1_A1_Y_sg13g2_nor2_1_B_Y_sg13g2_a21oi_1_B1_Y_sg13g2_nand3_1_A_Y_sg13g2_nor2_1_B/A
+ VDD uo_out_sg13g2_dfrbpq_1_Q_3_D_sg13g2_o21ai_1_Y_B1_sg13g2_nand2_1_Y_B_sg13g2_a22oi_1_Y_A1_sg13g2_a221oi_1_Y_C1_sg13g2_or4_1_X_B_sg13g2_o21ai_1_Y/B1
+ VSS operation\[3\]_sg13g2_dfrbpq_1_Q_D_sg13g2_a21oi_1_Y_A1_sg13g2_a21oi_1_A1_Y_sg13g2_nor2_1_B_Y_sg13g2_a21oi_1_B1_Y_sg13g2_nand3_1_A/Y
+ sg13g2_nor2_1
Xscan_reg\[23\]_sg13g2_nor2_1_A_1 scan_reg\[23\]_sg13g2_nor2_1_A/A VDD scan_reg\[23\]_sg13g2_nor2_1_A_1/Y
+ VSS scan_reg\[41\]_sg13g2_nor2_1_A/B sg13g2_nor2_1
Xoverflow_flag_sg13g2_dfrbpq_1_Q_D_sg13g2_inv_1_Y_A_sg13g2_o21ai_1_Y_B1_sg13g2_nand3_1_Y_A_sg13g2_nand2_1_Y_B_sg13g2_a21oi_1_Y_B1_sg13g2_or2_1_X
+ serial_a\[7\]_sg13g2_dfrbpq_1_Q/Q VSS serial_b\[7\]_sg13g2_dfrbpq_1_Q/Q overflow_flag_sg13g2_dfrbpq_1_Q_D_sg13g2_inv_1_Y_A_sg13g2_o21ai_1_Y_B1_sg13g2_nand3_1_Y_A_sg13g2_nand2_1_Y_B_sg13g2_a21oi_1_Y/B1
+ VDD sg13g2_or2_1
Xfault_counter\[1\]_sg13g2_dfrbpq_1_Q_D_sg13g2_xor2_1_X_B_sg13g2_and2_1_B_X_sg13g2_and3_1_C
+ fault_counter\[3\]_sg13g2_dfrbpq_1_Q_D_sg13g2_nor2_1_Y/A fault_counter\[2\]_sg13g2_dfrbpq_1_Q/Q
+ VDD VSS fault_counter\[2\]_sg13g2_dfrbpq_1_Q_D_sg13g2_xnor2_1_Y/B fault_counter\[3\]_sg13g2_dfrbpq_1_Q/Q
+ sg13g2_and3_1
Xcarry_flag_sg13g2_o21ai_1_A1_B1_sg13g2_nand2_1_Y_A_sg13g2_nand3_1_Y_C_sg13g2_and2_1_X
+ carry_flag_sg13g2_o21ai_1_A1_B1_sg13g2_nand2_1_Y_A_sg13g2_nand3_1_Y/C VSS VDD serial_opcode\[2\]_sg13g2_nor2_1_A/Y
+ serial_opcode\[1\]_sg13g2_nor2b_1_A/Y sg13g2_and2_1
Xoperand_a\[0\]_sg13g2_nor2_1_A operand_a\[0\]_sg13g2_nor2_1_A/A VDD operand_a\[0\]_sg13g2_nor2_1_A/Y
+ VSS ui_in[2] sg13g2_nor2_1
Xscan_reg\[43\]_sg13g2_dfrbpq_1_Q_D_sg13g2_a21oi_1_Y VDD VSS scan_out_sg13g2_a22oi_1_A1/B1
+ scan_reg\[44\]_sg13g2_inv_1_A/Y scan_reg\[43\]_sg13g2_o21ai_1_A1/Y scan_reg\[43\]_sg13g2_dfrbpq_1_Q/D
+ sg13g2_a21oi_1
Xuo_out_sg13g2_dfrbpq_1_Q_2_D_sg13g2_o21ai_1_Y_B1_sg13g2_nand3_1_Y_B_sg13g2_nand2_1_Y
+ uo_out_sg13g2_dfrbpq_1_Q_2_D_sg13g2_o21ai_1_Y_B1_sg13g2_nand3_1_Y/B VDD uo_out_sg13g2_dfrbpq_1_Q_2_D_sg13g2_o21ai_1_Y_B1_sg13g2_nand3_1_Y_B_sg13g2_nand2_1_Y/A
+ VSS uo_out_sg13g2_dfrbpq_1_Q_2_D_sg13g2_o21ai_1_Y_B1_sg13g2_nand3_1_Y_B_sg13g2_nand2_1_Y/B
+ sg13g2_nand2_1
Xuo_out_sg13g2_dfrbpq_1_Q_3_D_sg13g2_o21ai_1_Y_B1_sg13g2_nand2_1_Y_B_sg13g2_a22oi_1_Y_A1_sg13g2_a221oi_1_Y_C1_sg13g2_or4_1_X
+ uo_out_sg13g2_dfrbpq_1_Q_3_D_sg13g2_o21ai_1_Y_B1_sg13g2_nand2_1_Y_B_sg13g2_a22oi_1_Y_A1_sg13g2_a221oi_1_Y/C1
+ uo_out_sg13g2_dfrbpq_1_Q_3_D_sg13g2_o21ai_1_Y_B1_sg13g2_nand2_1_Y_B_sg13g2_a22oi_1_Y_A1_sg13g2_a221oi_1_Y_C1_sg13g2_or4_1_X/C
+ uo_out_sg13g2_dfrbpq_1_Q_3_D_sg13g2_o21ai_1_Y_B1_sg13g2_nand2_1_Y_B_sg13g2_a22oi_1_Y_A1_sg13g2_a221oi_1_Y_C1_sg13g2_or4_1_X/D
+ VDD VSS uo_out_sg13g2_dfrbpq_1_Q_3_D_sg13g2_o21ai_1_Y_B1_sg13g2_nand2_1_Y_B_sg13g2_a22oi_1_Y_A1_sg13g2_a221oi_1_Y_C1_sg13g2_or4_1_X/A
+ uo_out_sg13g2_dfrbpq_1_Q_3_D_sg13g2_o21ai_1_Y_B1_sg13g2_nand2_1_Y_B_sg13g2_a22oi_1_Y_A1_sg13g2_a221oi_1_Y_C1_sg13g2_or4_1_X/B
+ sg13g2_or4_1
Xclkbuf_5_5__f_clk clkload1/A VSS clkbuf_4_2_0_clk/X VDD sg13g2_buf_4
Xoperation\[3\]_sg13g2_nand2b_1_A_N VSS operation\[3\]_sg13g2_nor2_1_A/A scan_reg\[19\]_sg13g2_o21ai_1_A1/B1
+ ui_in[3] VDD sg13g2_nand2b_1
Xbist_a\[7\]_sg13g2_dfrbpq_1_Q VDD bist_a\[7\]_sg13g2_dfrbpq_1_Q/D bist_a\[7\]_sg13g2_or2_1_A/A
+ clkload0/A VSS rst_n sg13g2_dfrbpq_1
Xmisr\[1\]_sg13g2_inv_1_A_Y_sg13g2_xnor2_1_A_B_sg13g2_o21ai_1_Y_A2_sg13g2_nand3_1_Y_C_sg13g2_a22oi_1_Y_B1_sg13g2_and2_1_X_B_sg13g2_o21ai_1_Y
+ VSS VDD misr\[1\]_sg13g2_inv_1_A_Y_sg13g2_xnor2_1_A_B_sg13g2_o21ai_1_Y_A2_sg13g2_nand3_1_Y_C_sg13g2_a22oi_1_Y_B1_sg13g2_and2_1_X/B
+ misr\[1\]_sg13g2_inv_1_A_Y_sg13g2_xnor2_1_A_B_sg13g2_o21ai_1_Y_A2_sg13g2_nand3_1_Y_C_sg13g2_a22oi_1_Y_B1_sg13g2_and2_1_X_A_sg13g2_or3_1_X/A
+ misr\[1\]_sg13g2_inv_1_A_Y_sg13g2_xnor2_1_A_B_sg13g2_o21ai_1_Y_A2_sg13g2_nand3_1_Y_C_sg13g2_a22oi_1_Y_B1_sg13g2_and2_1_X_A_sg13g2_or3_1_X/C
+ misr\[1\]_sg13g2_inv_1_A_Y_sg13g2_xnor2_1_A_B_sg13g2_o21ai_1_Y_A2_sg13g2_nand3_1_Y_C_sg13g2_a22oi_1_Y_B1_sg13g2_and2_1_X_A_sg13g2_or3_1_X/B
+ sg13g2_o21ai_1
Xcycle_counter\[0\]_sg13g2_dfrbpq_1_Q VDD cycle_counter\[0\]_sg13g2_dfrbpq_1_Q/D cycle_counter\[0\]_sg13g2_dfrbpq_1_Q/Q
+ clkbuf_5_24__f_clk/X VSS rst_n sg13g2_dfrbpq_1
Xcarry_flag_sg13g2_o21ai_1_A1_B1_sg13g2_nand2_1_Y_B_sg13g2_a21oi_1_Y_A2_sg13g2_a21oi_1_Y
+ VDD VSS carry_flag_sg13g2_o21ai_1_A1_B1_sg13g2_nand2_1_Y_B_sg13g2_a21oi_1_Y_A2_sg13g2_a21oi_1_Y/A2
+ carry_flag_sg13g2_o21ai_1_A1_B1_sg13g2_nand2_1_Y_B_sg13g2_a21oi_1_Y_A2_sg13g2_a21oi_1_Y/A1
+ carry_flag_sg13g2_o21ai_1_A1_B1_sg13g2_nand2_1_Y_B_sg13g2_a21oi_1_Y_A2_sg13g2_a21oi_1_Y/B1
+ carry_flag_sg13g2_o21ai_1_A1_B1_sg13g2_nand2_1_Y_B_sg13g2_a21oi_1_Y/A2 sg13g2_a21oi_1
Xoverflow_flag_sg13g2_dfrbpq_1_Q_D_sg13g2_inv_1_Y_A_sg13g2_o21ai_1_Y_B1_sg13g2_nand3_1_Y_A_sg13g2_and4_1_A_X_sg13g2_nand3_1_B_A_sg13g2_or2_1_X_A_sg13g2_a21oi_1_Y
+ VDD VSS carry_flag_sg13g2_o21ai_1_A1_B1_sg13g2_nand2_1_Y_B_sg13g2_a21oi_1_Y/A1 uo_out_sg13g2_dfrbpq_1_Q_D_sg13g2_a21oi_1_Y_B1_sg13g2_a21oi_1_Y_A1_sg13g2_nand3_1_Y_B_sg13g2_a221oi_1_Y_C1_sg13g2_o21ai_1_Y_A1_sg13g2_a21oi_1_Y/A2
+ carry_flag_sg13g2_o21ai_1_A1_B1_sg13g2_nand2_1_Y_A_sg13g2_nand3_1_Y_A_sg13g2_a21oi_1_B1_Y_sg13g2_a22oi_1_B2/A1
+ overflow_flag_sg13g2_dfrbpq_1_Q_D_sg13g2_inv_1_Y_A_sg13g2_o21ai_1_Y_B1_sg13g2_nand3_1_Y_A_sg13g2_and4_1_A_X_sg13g2_nand3_1_B_A_sg13g2_or2_1_X/A
+ sg13g2_a21oi_1
Xmisr\[1\]_sg13g2_inv_1_A_Y_sg13g2_xnor2_1_A_B_sg13g2_o21ai_1_Y_A2_sg13g2_nand3_1_Y_B_sg13g2_nor3_1_Y_A_sg13g2_nor2_1_Y_B_sg13g2_nand2_1_Y
+ misr\[1\]_sg13g2_inv_1_A_Y_sg13g2_xnor2_1_A_B_sg13g2_o21ai_1_Y_A2_sg13g2_nand3_1_Y_B_sg13g2_nor3_1_Y_A_sg13g2_nor2_1_Y/B
+ VDD bist_a\[2\]_sg13g2_dfrbpq_1_Q_D_sg13g2_o21ai_1_Y/A1 VSS bist_a\[7\]_sg13g2_or2_1_A/B
+ sg13g2_nand2_1
Xuio_out_sg13g2_nand2_1_Y_A_sg13g2_nand2_1_Y uio_out_sg13g2_nand2_1_Y/A VDD cycle_counter\[7\]_sg13g2_dfrbpq_1_Q/Q
+ VSS bist_done_sg13g2_a22oi_1_B2/A2 sg13g2_nand2_1
Xcarry_flag_sg13g2_o21ai_1_A1_B1_sg13g2_nand2_1_Y_B_sg13g2_a21oi_1_Y_A2_sg13g2_a21oi_1_Y_B1_sg13g2_o21ai_1_B1_Y_sg13g2_a221oi_1_B1_1_Y_sg13g2_or4_1_C_A_sg13g2_nor2_1_Y
+ uo_out_sg13g2_dfrbpq_1_Q_3_D_sg13g2_o21ai_1_Y_B1_sg13g2_nand2_1_Y_B_sg13g2_a22oi_1_Y_A1_sg13g2_a221oi_1_Y_C1_sg13g2_or4_1_X_D_sg13g2_nor3_1_Y/B
+ VDD carry_flag_sg13g2_o21ai_1_A1_B1_sg13g2_nand2_1_Y_B_sg13g2_a21oi_1_Y_A2_sg13g2_a21oi_1_Y_B1_sg13g2_o21ai_1_B1_Y_sg13g2_a221oi_1_B1_1_Y_sg13g2_or4_1_C/A
+ VSS uo_out_sg13g2_dfrbpq_1_Q_3_D_sg13g2_o21ai_1_Y_B1_sg13g2_nand2_1_Y_B_sg13g2_a22oi_1_Y_A1_sg13g2_a221oi_1_Y_C1_sg13g2_or4_1_X_B_sg13g2_o21ai_1_Y/A2
+ sg13g2_nor2_1
Xscan_reg\[28\]_sg13g2_nand2b_1_B VSS ui_in[3] scan_reg\[28\]_sg13g2_nand2b_1_B/Y
+ scan_reg\[28\]_sg13g2_nand2b_1_B/B VDD sg13g2_nand2b_1
Xscan_reg\[27\]_sg13g2_dfrbpq_1_Q VDD scan_reg\[27\]_sg13g2_dfrbpq_1_Q/D scan_reg\[27\]_sg13g2_nor2_1_A/A
+ clkbuf_5_30__f_clk/X VSS rst_n sg13g2_dfrbpq_1
Xserial_b\[2\]_sg13g2_dfrbpq_1_Q_D_sg13g2_o21ai_1_Y_B1_sg13g2_nand2_1_Y serial_b\[2\]_sg13g2_dfrbpq_1_Q_D_sg13g2_o21ai_1_Y/B1
+ VDD serial_b\[3\]_sg13g2_inv_1_A/A VSS ui_in[1] sg13g2_nand2_1
Xscan_reg\[47\]_sg13g2_dfrbpq_1_Q VDD scan_reg\[47\]_sg13g2_dfrbpq_1_Q/D scan_reg\[47\]_sg13g2_nor2_1_A/A
+ clkbuf_5_10__f_clk/X VSS rst_n sg13g2_dfrbpq_1
Xlfsr\[1\]_sg13g2_dfrbpq_1_Q_D_sg13g2_inv_1_Y lfsr\[1\]_sg13g2_dfrbpq_1_Q/D lfsr\[1\]_sg13g2_a22oi_1_A1/Y
+ VSS VDD sg13g2_inv_1
Xuo_out_sg13g2_dfrbpq_1_Q_6_D_sg13g2_a21oi_1_Y_A2_sg13g2_a21o_1_X_A2_sg13g2_and2_1_X_A_sg13g2_a221oi_1_Y_B2_sg13g2_and2_1_X_B_sg13g2_o21ai_1_Y_A1_sg13g2_nor2_1_Y
+ serial_a\[3\]_sg13g2_dfrbpq_1_Q/Q VDD uo_out_sg13g2_dfrbpq_1_Q_6_D_sg13g2_a21oi_1_Y_A2_sg13g2_a21o_1_X_A2_sg13g2_and2_1_X_A_sg13g2_a221oi_1_Y_B2_sg13g2_and2_1_X_B_sg13g2_o21ai_1_Y/A1
+ VSS serial_b\[3\]_sg13g2_inv_1_A/Y sg13g2_nor2_1
Xfault_counter\[7\]_sg13g2_dfrbpq_1_Q_D_sg13g2_xnor2_1_Y fault_counter\[7\]_sg13g2_dfrbpq_1_Q/D
+ fault_counter\[7\]_sg13g2_dfrbpq_1_Q_D_sg13g2_xnor2_1_Y/B VDD fault_counter\[7\]_sg13g2_dfrbpq_1_Q/Q
+ VSS sg13g2_xnor2_1
Xscan_reg\[26\]_sg13g2_dfrbpq_1_Q_D_sg13g2_a221oi_1_Y_A2_sg13g2_inv_1_Y scan_reg\[26\]_sg13g2_dfrbpq_1_Q_D_sg13g2_a221oi_1_Y/A2
+ uo_out[6] VSS VDD sg13g2_inv_1
Xlfsr\[1\]_sg13g2_a22oi_1_A1_B2_sg13g2_inv_1_Y_A_sg13g2_dfrbpq_1_Q VDD lfsr\[1\]_sg13g2_a22oi_1_A1_B2_sg13g2_inv_1_Y_A_sg13g2_dfrbpq_1_Q/D
+ lfsr\[1\]_sg13g2_a22oi_1_A1_B2_sg13g2_inv_1_Y/A clkbuf_5_3__f_clk/X VSS rst_n sg13g2_dfrbpq_1
Xclkbuf_5_30__f_clk clkbuf_5_30__f_clk/X VSS clkbuf_4_15_0_clk/X VDD sg13g2_buf_4
Xmisr\[4\]_sg13g2_inv_1_A_Y_sg13g2_xnor2_1_A_B_sg13g2_o21ai_1_Y_A1_sg13g2_a21oi_1_Y
+ VDD VSS misr\[4\]_sg13g2_inv_1_A_Y_sg13g2_xnor2_1_A_B_sg13g2_o21ai_1_Y_A1_sg13g2_a21oi_1_Y/A2
+ uio_in[2] misr\[4\]_sg13g2_inv_1_A_Y_sg13g2_xnor2_1_A_B_sg13g2_o21ai_1_Y_A1_sg13g2_a21oi_1_Y/B1
+ misr\[4\]_sg13g2_inv_1_A_Y_sg13g2_xnor2_1_A_B_sg13g2_o21ai_1_Y/A1 sg13g2_a21oi_1
Xuo_out_sg13g2_dfrbpq_1_Q_5_D_sg13g2_a21oi_1_Y_A2_sg13g2_o21ai_1_Y_B1_sg13g2_or2_1_X_B_sg13g2_nand2_1_Y_A_sg13g2_a221oi_1_Y_C1_sg13g2_nand4_1_Y_B_sg13g2_o21ai_1_Y
+ VSS VDD uo_out_sg13g2_dfrbpq_1_Q_5_D_sg13g2_a21oi_1_Y_A2_sg13g2_o21ai_1_Y_B1_sg13g2_or2_1_X_B_sg13g2_nand2_1_Y_A_sg13g2_a221oi_1_Y_C1_sg13g2_nand4_1_Y/B
+ uo_out_sg13g2_dfrbpq_1_Q_5_D_sg13g2_a21oi_1_Y_A2_sg13g2_o21ai_1_Y_B1_sg13g2_or2_1_X_B_sg13g2_nand2_1_Y_A_sg13g2_a221oi_1_Y_C1_sg13g2_nand4_1_Y_B_sg13g2_o21ai_1_Y/B1
+ serial_a\[5\]_sg13g2_dfrbpq_1_Q/Q serial_b\[5\]_sg13g2_nand2b_1_B/B sg13g2_o21ai_1
Xoverflow_flag_sg13g2_dfrbpq_1_Q VDD overflow_flag_sg13g2_dfrbpq_1_Q/D overflow_flag_sg13g2_dfrbpq_1_Q/Q
+ clkbuf_5_27__f_clk/X VSS rst_n sg13g2_dfrbpq_1
Xuo_out_sg13g2_dfrbpq_1_Q_3_D_sg13g2_o21ai_1_Y_B1_sg13g2_nand2_1_Y_B_sg13g2_a22oi_1_Y_B2_sg13g2_mux2_1_X
+ misr\[4\]_sg13g2_inv_1_A_Y_sg13g2_xnor2_1_A_B_sg13g2_o21ai_1_Y_A2_sg13g2_o21ai_1_Y/A1
+ uo_out_sg13g2_dfrbpq_1_Q_3_D_sg13g2_o21ai_1_Y_B1_sg13g2_nand2_1_Y_B_sg13g2_a22oi_1_Y/B2
+ uo_out_sg13g2_dfrbpq_1_Q_3_D_sg13g2_o21ai_1_Y_B1_sg13g2_nand2_1_Y_B_sg13g2_a22oi_1_Y/A1
+ VDD VSS uo_out_sg13g2_dfrbpq_1_Q_3_D_sg13g2_o21ai_1_Y_B1_sg13g2_nand2_1_Y_B_sg13g2_a22oi_1_Y_B2_sg13g2_mux2_1_X/A0
+ sg13g2_mux2_1
Xuo_out_sg13g2_dfrbpq_1_Q_D_sg13g2_a21oi_1_Y_B1_sg13g2_a21oi_1_Y_A1_sg13g2_nand3_1_Y_B_sg13g2_a221oi_1_Y
+ uo_out_sg13g2_dfrbpq_1_Q_D_sg13g2_a21oi_1_Y_B1_sg13g2_a21oi_1_Y_A1_sg13g2_nand3_1_Y_B_sg13g2_a221oi_1_Y/C1
+ uo_out_sg13g2_dfrbpq_1_Q_D_sg13g2_a21oi_1_Y_B1_sg13g2_a21oi_1_Y_A1_sg13g2_nand3_1_Y/B
+ uo_out_sg13g2_dfrbpq_1_Q_D_sg13g2_a21oi_1_Y_B1_sg13g2_a21oi_1_Y_A1_sg13g2_nand3_1_Y_B_sg13g2_a221oi_1_Y/B2
+ uo_out_sg13g2_dfrbpq_1_Q_D_sg13g2_a21oi_1_Y_B1_sg13g2_a21oi_1_Y_A1_sg13g2_nand3_1_Y_B_sg13g2_a221oi_1_Y/B1
+ uo_out_sg13g2_dfrbpq_1_Q_6_D_sg13g2_a21oi_1_Y_A2_sg13g2_a21o_1_X_A2_sg13g2_and2_1_X_B_sg13g2_a22oi_1_Y/A2
+ VDD serial_b\[3\]_sg13g2_inv_1_A/A VSS sg13g2_a221oi_1
Xbist_pattern_count\[6\]_sg13g2_dfrbpq_1_Q VDD bist_pattern_count\[6\]_sg13g2_dfrbpq_1_Q/D
+ bist_pattern_count\[6\]_sg13g2_nand3_1_C/C clkbuf_5_2__f_clk/X VSS rst_n sg13g2_dfrbpq_1
Xbist_pattern_count\[2\]_sg13g2_dfrbpq_1_Q_D_sg13g2_nor3_1_Y bist_pattern_count\[3\]_sg13g2_nor2_1_A/B
+ bist_pattern_count\[2\]_sg13g2_dfrbpq_1_Q/D bist_fault_sg13g2_dfrbpq_1_Q_D_sg13g2_nor3_1_Y/A
+ bist_pattern_count\[2\]_sg13g2_dfrbpq_1_Q_D_sg13g2_nor3_1_Y/C VDD VSS sg13g2_nor3_1
Xcycle_counter\[5\]_sg13g2_dfrbpq_1_Q_D_sg13g2_and2_1_X_A_sg13g2_nand3_1_Y VDD cycle_counter\[5\]_sg13g2_dfrbpq_1_Q_D_sg13g2_and2_1_X/A
+ cycle_counter\[5\]_sg13g2_dfrbpq_1_Q/Q cycle_counter\[4\]_sg13g2_dfrbpq_1_Q_D_sg13g2_xnor2_1_Y/B
+ bist_done_sg13g2_a22oi_1_B2/A1 VSS sg13g2_nand3_1
Xbist_pattern_count\[6\]_sg13g2_nand3_1_C VDD bist_pattern_count\[6\]_sg13g2_nand3_1_C/Y
+ bist_pattern_count\[6\]_sg13g2_nand3_1_C/B bist_pattern_count\[6\]_sg13g2_nand3_1_C/C
+ bist_pattern_count\[4\]_sg13g2_and2_1_A/A VSS sg13g2_nand3_1
Xoverflow_flag_sg13g2_dfrbpq_1_Q_D_sg13g2_inv_1_Y_A_sg13g2_o21ai_1_Y_B1_sg13g2_nand3_1_Y_A_sg13g2_and4_1_A_C_sg13g2_o21ai_1_Y_B1_sg13g2_and2_1_X
+ overflow_flag_sg13g2_dfrbpq_1_Q_D_sg13g2_inv_1_Y_A_sg13g2_o21ai_1_Y_B1_sg13g2_nand3_1_Y_A_sg13g2_and4_1_A_C_sg13g2_o21ai_1_Y/B1
+ VSS VDD serial_b\[7\]_sg13g2_dfrbpq_1_Q/Q serial_a\[7\]_sg13g2_dfrbpq_1_Q/Q sg13g2_and2_1
Xserial_b\[6\]_sg13g2_dfrbpq_1_Q_D_sg13g2_mux2_1_X serial_b\[7\]_sg13g2_dfrbpq_1_Q/Q
+ serial_b\[6\]_sg13g2_dfrbpq_1_Q/D ui_in[1] VDD VSS serial_b\[6\]_sg13g2_and2_1_A/A
+ sg13g2_mux2_1
Xscan_reg\[40\]_sg13g2_a22oi_1_B1 scan_reg\[40\]_sg13g2_a22oi_1_B1/Y ui_in[3] VDD
+ scan_reg\[40\]_sg13g2_dfrbpq_1_Q/Q misr\[7\]_sg13g2_dfrbpq_1_Q/Q VSS scan_out_sg13g2_a22oi_1_A1/B1
+ sg13g2_a22oi_1
Xbist_a\[7\]_sg13g2_dfrbpq_1_Q_D_sg13g2_o21ai_1_Y_A1_sg13g2_nand2_1_A_B_sg13g2_o21ai_1_A2_B1_sg13g2_a21oi_1_Y_A2_sg13g2_a21o_1_X
+ bist_a\[7\]_sg13g2_dfrbpq_1_Q_D_sg13g2_o21ai_1_Y_A1_sg13g2_o21ai_1_A1_B1_sg13g2_a21oi_1_Y/A2
+ bist_a\[7\]_sg13g2_dfrbpq_1_Q_D_sg13g2_o21ai_1_Y_A1_sg13g2_nand2_1_A_B_sg13g2_o21ai_1_A2_B1_sg13g2_a21oi_1_Y/A2
+ VDD VSS bist_a\[1\]_sg13g2_dfrbpq_1_Q/Q bist_a\[7\]_sg13g2_dfrbpq_1_Q_D_sg13g2_o21ai_1_Y_A1_sg13g2_nand2_1_A_Y_sg13g2_a221oi_1_A1_A2_sg13g2_nand3_1_Y_C_sg13g2_nand3_1_Y/C
+ sg13g2_a21o_1
Xbist_state\[3\]_sg13g2_dfrbpq_1_Q_D_sg13g2_o21ai_1_Y_B1_sg13g2_nand2_1_Y bist_state\[3\]_sg13g2_dfrbpq_1_Q_D_sg13g2_o21ai_1_Y/B1
+ VDD bist_fault_sg13g2_o21ai_1_A2/B1 VSS ui_in[7] sg13g2_nand2_1
Xoperand_b\[1\]_sg13g2_dfrbpq_1_Q VDD operand_b\[1\]_sg13g2_dfrbpq_1_Q/D operand_b\[1\]_sg13g2_inv_1_A/A
+ clkload3/A VSS rst_n sg13g2_dfrbpq_1
Xcarry_flag_sg13g2_o21ai_1_A1_B1_sg13g2_nand2_1_Y_A_sg13g2_nand3_1_Y_B_sg13g2_nand3_1_C_A_sg13g2_o21ai_1_B1
+ VSS VDD carry_flag_sg13g2_o21ai_1_A1_B1_sg13g2_nand2_1_Y_A_sg13g2_nand3_1_Y_B_sg13g2_nand3_1_C_A_sg13g2_o21ai_1_B1/Y
+ carry_flag_sg13g2_o21ai_1_A1_B1_sg13g2_nand2_1_Y_A_sg13g2_nand3_1_Y_B_sg13g2_nand3_1_C/A
+ carry_flag_sg13g2_o21ai_1_A1_B1_sg13g2_nand2_1_Y_A_sg13g2_nand3_1_Y_B_sg13g2_nand3_1_C_A_sg13g2_o21ai_1_B1/A2
+ carry_flag_sg13g2_o21ai_1_A1_B1_sg13g2_nand2_1_Y_A_sg13g2_nand3_1_Y_B_sg13g2_nand3_1_C_A_sg13g2_o21ai_1_B1/A1
+ sg13g2_o21ai_1
Xuo_out_sg13g2_dfrbpq_1_Q_5_D_sg13g2_a21oi_1_Y_A2_sg13g2_o21ai_1_Y_A2_sg13g2_mux2_1_X_A1_sg13g2_or2_1_X
+ uo_out_sg13g2_dfrbpq_1_Q_D_sg13g2_a21oi_1_Y_B1_sg13g2_a21oi_1_Y_A1_sg13g2_nand3_1_Y_C_sg13g2_nand4_1_Y/D
+ VSS misr\[4\]_sg13g2_inv_1_A_Y_sg13g2_xnor2_1_A_B_sg13g2_o21ai_1_Y_B1_sg13g2_or2_1_X_B_sg13g2_nor2_1_Y/B
+ uo_out_sg13g2_dfrbpq_1_Q_5_D_sg13g2_a21oi_1_Y_A2_sg13g2_o21ai_1_Y_A2_sg13g2_mux2_1_X/A1
+ VDD sg13g2_or2_1
Xcarry_flag_sg13g2_o21ai_1_A1_B1_sg13g2_nand2_1_Y_A_sg13g2_nand3_1_Y_B_sg13g2_nand3_1_Y_A_sg13g2_nand2b_1_Y
+ VSS serial_b\[7\]_sg13g2_dfrbpq_1_Q/Q carry_flag_sg13g2_o21ai_1_A1_B1_sg13g2_nand2_1_Y_A_sg13g2_nand3_1_Y_B_sg13g2_nand3_1_Y/A
+ serial_a\[7\]_sg13g2_dfrbpq_1_Q/Q VDD sg13g2_nand2b_1
Xfault_counter\[3\]_sg13g2_dfrbpq_1_Q_D_sg13g2_nor2_1_Y_B_sg13g2_a21oi_1_Y VDD VSS
+ fault_counter\[2\]_sg13g2_dfrbpq_1_Q_D_sg13g2_xnor2_1_Y/B fault_counter\[2\]_sg13g2_dfrbpq_1_Q/Q
+ fault_counter\[3\]_sg13g2_dfrbpq_1_Q/Q fault_counter\[3\]_sg13g2_dfrbpq_1_Q_D_sg13g2_nor2_1_Y/B
+ sg13g2_a21oi_1
Xuo_out_sg13g2_dfrbpq_1_Q_6_D_sg13g2_a21oi_1_Y_A2_sg13g2_a21o_1_X_A2_sg13g2_and2_1_X_B_sg13g2_a22oi_1_Y_B2_sg13g2_and2_1_X_B_sg13g2_o21ai_1_Y_A2_sg13g2_a221oi_1_Y_C1_sg13g2_and2_1_X
+ uo_out_sg13g2_dfrbpq_1_Q_6_D_sg13g2_a21oi_1_Y_A2_sg13g2_a21o_1_X_A2_sg13g2_and2_1_X_B_sg13g2_a22oi_1_Y_B2_sg13g2_and2_1_X_B_sg13g2_o21ai_1_Y_A2_sg13g2_a221oi_1_Y/C1
+ VSS VDD serial_b\[2\]_sg13g2_xor2_1_A/B serial_b\[2\]_sg13g2_xor2_1_A/A sg13g2_and2_1
Xoverflow_flag_sg13g2_dfrbpq_1_Q_D_sg13g2_inv_1_Y_A_sg13g2_o21ai_1_Y_B1_sg13g2_nand3_1_Y_C_sg13g2_a21oi_1_Y_A1_sg13g2_o21ai_1_A2_A1_sg13g2_nand2b_1_Y
+ VSS serial_opcode\[2\]_sg13g2_nand2_1_A/Y overflow_flag_sg13g2_dfrbpq_1_Q_D_sg13g2_inv_1_Y_A_sg13g2_o21ai_1_Y_B1_sg13g2_nand3_1_Y_C_sg13g2_a21oi_1_Y_A1_sg13g2_o21ai_1_A2/A1
+ serial_opcode\[1\]_sg13g2_nor2b_1_B_N/Y VDD sg13g2_nand2b_1
Xscan_reg\[13\]_sg13g2_dfrbpq_1_Q_D_sg13g2_a221oi_1_Y scan_reg\[13\]_sg13g2_nor2_1_A_1/Y
+ scan_reg\[13\]_sg13g2_dfrbpq_1_Q/D scan_reg\[14\]_sg13g2_inv_1_A/Y scan_out_sg13g2_a22oi_1_A1/B1
+ operand_b\[5\]_sg13g2_inv_1_A/Y VDD ui_in[3] VSS sg13g2_a221oi_1
Xscan_reg\[21\]_sg13g2_nor2_1_A scan_reg\[21\]_sg13g2_nor2_1_A/A VDD scan_reg\[21\]_sg13g2_nor2_1_A/Y
+ VSS scan_reg\[3\]_sg13g2_nor2_1_A/B sg13g2_nor2_1
Xserial_a\[4\]_sg13g2_dfrbpq_1_Q_D_sg13g2_mux2_1_X serial_a\[5\]_sg13g2_dfrbpq_1_Q/Q
+ serial_a\[4\]_sg13g2_dfrbpq_1_Q/D ui_in[1] VDD VSS serial_b\[4\]_sg13g2_nand2_1_A/B
+ sg13g2_mux2_1
Xbist_a\[2\]_sg13g2_dfrbpq_1_Q_D_sg13g2_o21ai_1_Y VSS VDD bist_a\[2\]_sg13g2_dfrbpq_1_Q/D
+ lfsr\[2\]_sg13g2_nand2_1_A/Y lfsr\[7\]_sg13g2_nand2_1_A/B bist_a\[2\]_sg13g2_dfrbpq_1_Q_D_sg13g2_o21ai_1_Y/A1
+ sg13g2_o21ai_1
Xuio_out_sg13g2_nand2_1_Y_5_B_sg13g2_a22oi_1_Y uio_out_sg13g2_nand2_1_Y_5/B bist_done_sg13g2_a22oi_1_B2/A2
+ VDD misr\[4\]_sg13g2_a22oi_1_B2/B1 cycle_counter\[6\]_sg13g2_dfrbpq_1_Q/Q VSS misr\[6\]_sg13g2_dfrbpq_1_Q/Q
+ sg13g2_a22oi_1
Xscan_reg\[47\]_sg13g2_nor2_1_A scan_reg\[47\]_sg13g2_nor2_1_A/A VDD scan_reg\[47\]_sg13g2_nor2_1_A/Y
+ VSS scan_reg\[3\]_sg13g2_nor2_1_A/B sg13g2_nor2_1
Xlfsr\[7\]_sg13g2_dfrbpq_1_Q VDD lfsr\[7\]_sg13g2_dfrbpq_1_Q/D lfsr\[7\]_sg13g2_xnor2_1_B/B
+ clkbuf_5_0__f_clk/X VSS rst_n sg13g2_dfrbpq_1
Xscan_reg\[32\]_sg13g2_o21ai_1_A1 VSS VDD scan_reg\[32\]_sg13g2_o21ai_1_A1/Y scan_reg\[32\]_sg13g2_o21ai_1_A1/B1
+ scan_reg\[3\]_sg13g2_nor2_1_A/B scan_reg\[32\]_sg13g2_nor2_1_A/A sg13g2_o21ai_1
Xscan_reg\[52\]_sg13g2_inv_1_A scan_reg\[52\]_sg13g2_inv_1_A/Y scan_reg\[52\]_sg13g2_inv_1_A/A
+ VSS VDD sg13g2_inv_1
Xuo_out_sg13g2_dfrbpq_1_Q VDD uo_out_sg13g2_dfrbpq_1_Q/D uo_out[3] clkbuf_5_26__f_clk/X
+ VSS rst_n sg13g2_dfrbpq_1
Xbist_a\[7\]_sg13g2_dfrbpq_1_Q_D_sg13g2_o21ai_1_Y_A1_sg13g2_nand2_1_A_B_sg13g2_inv_1_Y
+ bist_a\[7\]_sg13g2_dfrbpq_1_Q_D_sg13g2_o21ai_1_Y_A1_sg13g2_nand2_1_A/B bist_a\[7\]_sg13g2_dfrbpq_1_Q_D_sg13g2_o21ai_1_Y_A1_sg13g2_nand2_1_A_B_sg13g2_inv_1_Y/A
+ VSS VDD sg13g2_inv_1
Xmisr\[1\]_sg13g2_inv_1_A_Y_sg13g2_xnor2_1_A_B_sg13g2_o21ai_1_Y_B1_sg13g2_nand4_1_Y
+ VDD misr\[1\]_sg13g2_inv_1_A_Y_sg13g2_xnor2_1_A_B_sg13g2_o21ai_1_Y/B1 misr\[1\]_sg13g2_inv_1_A_Y_sg13g2_xnor2_1_A_B_sg13g2_o21ai_1_Y/A1
+ misr\[1\]_sg13g2_inv_1_A_Y_sg13g2_xnor2_1_A_B_sg13g2_o21ai_1_Y_B1_sg13g2_nand4_1_Y/C
+ VSS misr\[1\]_sg13g2_inv_1_A_Y_sg13g2_xnor2_1_A_B_sg13g2_o21ai_1_Y_B1_sg13g2_nand4_1_Y/A
+ misr\[1\]_sg13g2_inv_1_A_Y_sg13g2_xnor2_1_A_B_sg13g2_o21ai_1_Y_B1_sg13g2_nand4_1_Y/D
+ sg13g2_nand4_1
Xserial_b\[0\]_sg13g2_dfrbpq_1_Q VDD serial_b\[0\]_sg13g2_dfrbpq_1_Q/D serial_b\[0\]_sg13g2_xnor2_1_B/B
+ clkbuf_5_16__f_clk/X VSS rst_n sg13g2_dfrbpq_1
Xscan_reg\[24\]_sg13g2_dfrbpq_1_Q_D_sg13g2_a221oi_1_Y_A2_sg13g2_inv_1_Y scan_reg\[24\]_sg13g2_dfrbpq_1_Q_D_sg13g2_a221oi_1_Y/A2
+ uo_out[4] VSS VDD sg13g2_inv_1
Xbist_state\[3\]_sg13g2_inv_1_A_Y_sg13g2_a21o_1_A1 ui_in[7] bist_state\[3\]_sg13g2_inv_1_A_Y_sg13g2_a21o_1_A1/X
+ VDD VSS bist_state\[3\]_sg13g2_inv_1_A/Y bist_state\[1\]_sg13g2_a21oi_1_A1/A2 sg13g2_a21o_1
Xbist_a\[7\]_sg13g2_dfrbpq_1_Q_D_sg13g2_o21ai_1_Y_A1_sg13g2_o21ai_1_A1_B1_sg13g2_a21oi_1_Y_A2_sg13g2_and2_1_X_A_sg13g2_nor2_1_Y
+ bist_a\[2\]_sg13g2_dfrbpq_1_Q_D_sg13g2_o21ai_1_Y/A1 VDD bist_a\[7\]_sg13g2_dfrbpq_1_Q_D_sg13g2_o21ai_1_Y_A1_sg13g2_o21ai_1_A1_B1_sg13g2_a21oi_1_Y_A2_sg13g2_and2_1_X/A
+ VSS bist_a\[7\]_sg13g2_or2_1_A/B sg13g2_nor2_1
Xuo_out_sg13g2_dfrbpq_1_Q_3_D_sg13g2_o21ai_1_Y_B1_sg13g2_nand2_1_Y_B_sg13g2_a22oi_1_Y_B1_sg13g2_a21oi_1_Y
+ VDD VSS negative_flag_sg13g2_dfrbpq_1_Q_D_sg13g2_a21oi_1_Y_A2_sg13g2_o21ai_1_Y_B1_sg13g2_nand2b_1_Y/A_N
+ uio_in[1] negative_flag_sg13g2_dfrbpq_1_Q_D_sg13g2_a21oi_1_Y_A2_sg13g2_o21ai_1_Y/A1
+ uo_out_sg13g2_dfrbpq_1_Q_3_D_sg13g2_o21ai_1_Y_B1_sg13g2_nand2_1_Y_B_sg13g2_a22oi_1_Y/B1
+ sg13g2_a21oi_1
Xscan_reg\[41\]_sg13g2_a21oi_1_A1 VDD VSS ui_in[6] scan_reg\[41\]_sg13g2_nor2_1_A/A
+ ui_in[3] scan_reg\[41\]_sg13g2_a21oi_1_A1/Y sg13g2_a21oi_1
Xmisr\[7\]_sg13g2_dfrbpq_1_Q_D_sg13g2_a22oi_1_Y_B2_sg13g2_o21ai_1_Y_A2_sg13g2_a22oi_1_Y_A1_sg13g2_a21oi_1_Y
+ VDD VSS bist_a\[7\]_sg13g2_dfrbpq_1_Q_D_sg13g2_o21ai_1_Y_A1_sg13g2_nand2_1_A_Y_sg13g2_a221oi_1_B2/A1
+ misr\[7\]_sg13g2_dfrbpq_1_Q_D_sg13g2_a22oi_1_Y_B2_sg13g2_o21ai_1_Y_A2_sg13g2_a22oi_1_Y_A1_sg13g2_a21oi_1_Y/A1
+ misr\[7\]_sg13g2_dfrbpq_1_Q_D_sg13g2_a22oi_1_Y_B2_sg13g2_o21ai_1_Y_A2_sg13g2_a22oi_1_Y_A1_sg13g2_a21oi_1_Y/B1
+ misr\[7\]_sg13g2_dfrbpq_1_Q_D_sg13g2_a22oi_1_Y_B2_sg13g2_o21ai_1_Y_A2_sg13g2_a22oi_1_Y/A1
+ sg13g2_a21oi_1
Xbist_state\[3\]_sg13g2_dfrbpq_1_Q_D_sg13g2_o21ai_1_Y VSS VDD bist_state\[3\]_sg13g2_dfrbpq_1_Q/D
+ bist_state\[3\]_sg13g2_dfrbpq_1_Q_D_sg13g2_o21ai_1_Y/B1 bist_state\[2\]_sg13g2_dfrbpq_1_Q_D_sg13g2_a21o_1_X/A2
+ bist_state\[1\]_sg13g2_inv_1_A/Y sg13g2_o21ai_1
Xmisr\[4\]_sg13g2_inv_1_A_Y_sg13g2_xnor2_1_A_B_sg13g2_o21ai_1_Y_B1_sg13g2_or2_1_X_A_sg13g2_nand3_1_Y_B_sg13g2_a22oi_1_Y_A2_sg13g2_a21oi_1_Y
+ VDD VSS bist_a\[7\]_sg13g2_dfrbpq_1_Q_D_sg13g2_o21ai_1_Y_A1_sg13g2_o21ai_1_A1_Y_sg13g2_nand2b_1_A_N_Y_sg13g2_a221oi_1_C1_B1_sg13g2_mux2_1_X/S
+ bist_a\[1\]_sg13g2_dfrbpq_1_Q_D_sg13g2_o21ai_1_Y/A1 misr\[4\]_sg13g2_inv_1_A_Y_sg13g2_xnor2_1_A_B_sg13g2_o21ai_1_Y_B1_sg13g2_or2_1_X_A_sg13g2_nand3_1_Y_B_sg13g2_a22oi_1_Y_A2_sg13g2_a21oi_1_Y/B1
+ misr\[4\]_sg13g2_inv_1_A_Y_sg13g2_xnor2_1_A_B_sg13g2_o21ai_1_Y_B1_sg13g2_or2_1_X_A_sg13g2_nand3_1_Y_B_sg13g2_a22oi_1_Y/A2
+ sg13g2_a21oi_1
Xlfsr\[7\]_sg13g2_xnor2_1_B_Y_sg13g2_xnor2_1_A_Y_sg13g2_a22oi_1_B2_Y_sg13g2_inv_1_A
+ lfsr\[1\]_sg13g2_a22oi_1_A1_B2_sg13g2_inv_1_Y_A_sg13g2_dfrbpq_1_Q/D lfsr\[7\]_sg13g2_xnor2_1_B_Y_sg13g2_xnor2_1_A_Y_sg13g2_a22oi_1_B2/Y
+ VSS VDD sg13g2_inv_1
Xcarry_flag_sg13g2_o21ai_1_A1_B1_sg13g2_nand2_1_Y_B_sg13g2_a21oi_1_Y_A2_sg13g2_a21oi_1_Y_B1_sg13g2_o21ai_1_B1_Y_sg13g2_a221oi_1_B1_1_Y_sg13g2_or4_1_C_B_sg13g2_nor3_1_Y_C_sg13g2_xnor2_1_Y
+ carry_flag_sg13g2_o21ai_1_A1_B1_sg13g2_nand2_1_Y_B_sg13g2_a21oi_1_Y_A2_sg13g2_a21oi_1_Y_B1_sg13g2_o21ai_1_B1_Y_sg13g2_a221oi_1_B1_1_Y_sg13g2_or4_1_C_B_sg13g2_nor3_1_Y/C
+ uo_out_sg13g2_dfrbpq_1_Q_D_sg13g2_a21oi_1_Y_B1_sg13g2_a21oi_1_Y_A1_sg13g2_nand3_1_Y_B_sg13g2_a221oi_1_Y_B1_sg13g2_xnor2_1_Y_A_sg13g2_a21oi_1_Y/A2
+ VDD uo_out_sg13g2_dfrbpq_1_Q_D_sg13g2_a21oi_1_Y_B1_sg13g2_a21oi_1_Y_A1_sg13g2_nand3_1_Y_B_sg13g2_a221oi_1_Y_B1_sg13g2_xnor2_1_Y_A_sg13g2_a21oi_1_Y/A1
+ VSS sg13g2_xnor2_1
Xmisr\[6\]_sg13g2_dfrbpq_1_Q_D_sg13g2_o21ai_1_Y_A2_sg13g2_xnor2_1_Y_B_sg13g2_a22oi_1_Y_B2_sg13g2_a22oi_1_Y
+ misr\[6\]_sg13g2_dfrbpq_1_Q_D_sg13g2_o21ai_1_Y_A2_sg13g2_xnor2_1_Y_B_sg13g2_a22oi_1_Y/B2
+ misr\[6\]_sg13g2_dfrbpq_1_Q_D_sg13g2_o21ai_1_Y_A2_sg13g2_xnor2_1_Y_B_sg13g2_a22oi_1_Y/A1
+ VDD misr\[4\]_sg13g2_inv_1_A_Y_sg13g2_xnor2_1_A_B_sg13g2_o21ai_1_Y_B1_sg13g2_or2_1_X/A
+ uo_out_sg13g2_dfrbpq_1_Q_5_D_sg13g2_a21oi_1_Y_A2_sg13g2_o21ai_1_Y_A2_sg13g2_mux2_1_X/A0
+ VSS uio_in[1] sg13g2_a22oi_1
Xuio_out_sg13g2_nand2_1_Y_2_A_sg13g2_a22oi_1_Y uio_out_sg13g2_nand2_1_Y_2/A bist_done_sg13g2_a22oi_1_B2/A2
+ VDD misr\[4\]_sg13g2_a22oi_1_B2/B1 cycle_counter\[2\]_sg13g2_dfrbpq_1_Q/Q VSS misr\[2\]_sg13g2_dfrbpq_1_Q/Q
+ sg13g2_a22oi_1
Xclkbuf_5_13__f_clk clkbuf_5_13__f_clk/X VSS clkbuf_4_6_0_clk/X VDD sg13g2_buf_4
Xbist_state\[2\]_sg13g2_dfrbpq_1_Q_D_sg13g2_a21o_1_X bist_state\[1\]_sg13g2_a21oi_1_A1/B1
+ bist_state\[2\]_sg13g2_dfrbpq_1_Q/D VDD VSS bist_state\[1\]_sg13g2_inv_1_A/A bist_state\[2\]_sg13g2_dfrbpq_1_Q_D_sg13g2_a21o_1_X/A2
+ sg13g2_a21o_1
Xoperand_a\[0\]_sg13g2_nand2b_1_A_N VSS operand_a\[0\]_sg13g2_nor2_1_A/A scan_reg\[1\]_sg13g2_o21ai_1_A1/B1
+ ui_in[3] VDD sg13g2_nand2b_1
Xuo_out_sg13g2_dfrbpq_1_Q_6_D_sg13g2_a21oi_1_Y_A2_sg13g2_a21o_1_X_A2_sg13g2_and2_1_X_B_sg13g2_a22oi_1_Y_B2_sg13g2_and2_1_X_B_sg13g2_o21ai_1_Y_A2_sg13g2_a221oi_1_Y
+ uo_out_sg13g2_dfrbpq_1_Q_6_D_sg13g2_a21oi_1_Y_A2_sg13g2_a21o_1_X_A2_sg13g2_and2_1_X_B_sg13g2_a22oi_1_Y_B2_sg13g2_and2_1_X_B_sg13g2_o21ai_1_Y_A2_sg13g2_a221oi_1_Y/C1
+ uo_out_sg13g2_dfrbpq_1_Q_6_D_sg13g2_a21oi_1_Y_A2_sg13g2_a21o_1_X_A2_sg13g2_and2_1_X_B_sg13g2_a22oi_1_Y_B2_sg13g2_and2_1_X_B_sg13g2_o21ai_1_Y/A2
+ carry_flag_sg13g2_o21ai_1_A1_B1_sg13g2_nand2_1_Y_B_sg13g2_a21oi_1_Y_A2_sg13g2_a21oi_1_Y_B1_sg13g2_o21ai_1_B1_Y_sg13g2_a221oi_1_B1_1_B2_sg13g2_xnor2_1_Y/B
+ serial_b\[2\]_sg13g2_xor2_1_A/X serial_b\[3\]_sg13g2_inv_1_A/A VDD serial_a\[3\]_sg13g2_dfrbpq_1_Q/Q
+ VSS sg13g2_a221oi_1
Xuo_out_sg13g2_dfrbpq_1_Q_1_D_sg13g2_a21oi_1_Y_A2_sg13g2_o21ai_1_Y_A2_sg13g2_o21ai_1_Y_A2_sg13g2_and2_1_B
+ misr\[1\]_sg13g2_inv_1_A_Y_sg13g2_xnor2_1_A_B_sg13g2_o21ai_1_Y/A1 VSS VDD uo_out_sg13g2_dfrbpq_1_Q_1_D_sg13g2_a21oi_1_Y_A2_sg13g2_o21ai_1_Y_A2_sg13g2_o21ai_1_Y/A2
+ uio_in[0] sg13g2_and2_1
Xcarry_flag_sg13g2_o21ai_1_A1_B1_sg13g2_nand2_1_Y_B_sg13g2_a21oi_1_Y VDD VSS carry_flag_sg13g2_o21ai_1_A1_B1_sg13g2_nand2_1_Y_B_sg13g2_a21oi_1_Y/A2
+ carry_flag_sg13g2_o21ai_1_A1_B1_sg13g2_nand2_1_Y_B_sg13g2_a21oi_1_Y/A1 zero_flag_sg13g2_nand2_1_A/B
+ carry_flag_sg13g2_o21ai_1_A1_B1_sg13g2_nand2_1_Y/B sg13g2_a21oi_1
Xcarry_flag_sg13g2_o21ai_1_A1_B1_sg13g2_nand2_1_Y_B_sg13g2_a21oi_1_Y_A2_sg13g2_a21oi_1_Y_B1_sg13g2_nor2_1_Y
+ serial_a\[7\]_sg13g2_dfrbpq_1_Q/Q VDD carry_flag_sg13g2_o21ai_1_A1_B1_sg13g2_nand2_1_Y_B_sg13g2_a21oi_1_Y_A2_sg13g2_a21oi_1_Y/B1
+ VSS serial_b\[7\]_sg13g2_dfrbpq_1_Q/Q sg13g2_nor2_1
Xoverflow_flag_sg13g2_dfrbpq_1_Q_D_sg13g2_inv_1_Y_A_sg13g2_o21ai_1_Y_B1_sg13g2_nand3_1_Y_C_sg13g2_a21oi_1_Y_A1_sg13g2_o21ai_1_A2_B1_sg13g2_o21ai_1_A1_Y_sg13g2_nor2_1_B_A_sg13g2_nand3_1_Y_A_sg13g2_o21ai_1_Y
+ VSS VDD overflow_flag_sg13g2_dfrbpq_1_Q_D_sg13g2_inv_1_Y_A_sg13g2_o21ai_1_Y_B1_sg13g2_nand3_1_Y_C_sg13g2_a21oi_1_Y_A1_sg13g2_o21ai_1_A2_B1_sg13g2_o21ai_1_A1_Y_sg13g2_nor2_1_B_A_sg13g2_nand3_1_Y/A
+ serial_opcode\[2\]_sg13g2_nor3_1_A/Y serial_b\[2\]_sg13g2_xor2_1_A/B serial_b\[2\]_sg13g2_xor2_1_A/A
+ sg13g2_o21ai_1
Xbist_a\[7\]_sg13g2_dfrbpq_1_Q_D_sg13g2_o21ai_1_Y_A1_sg13g2_nand2_1_A_B_sg13g2_inv_1_Y_A_sg13g2_nor2_1_Y
+ bist_a\[1\]_sg13g2_dfrbpq_1_Q/Q VDD bist_a\[7\]_sg13g2_dfrbpq_1_Q_D_sg13g2_o21ai_1_Y_A1_sg13g2_nand2_1_A_B_sg13g2_inv_1_Y/A
+ VSS bist_a\[7\]_sg13g2_dfrbpq_1_Q_D_sg13g2_o21ai_1_Y_A1_sg13g2_nand2_1_A_B_sg13g2_inv_1_Y_A_sg13g2_nor2_1_Y/B
+ sg13g2_nor2_1
Xscan_reg\[56\]_sg13g2_o21ai_1_A1_B1_sg13g2_nand2b_1_Y VSS cycle_counter\[6\]_sg13g2_dfrbpq_1_Q/Q
+ scan_reg\[56\]_sg13g2_o21ai_1_A1/B1 ui_in[3] VDD sg13g2_nand2b_1
Xmisr\[4\]_sg13g2_inv_1_A_Y_sg13g2_xnor2_1_A_B_sg13g2_o21ai_1_Y_A2_sg13g2_o21ai_1_Y_A1_sg13g2_nand2_1_Y
+ misr\[4\]_sg13g2_inv_1_A_Y_sg13g2_xnor2_1_A_B_sg13g2_o21ai_1_Y_A2_sg13g2_o21ai_1_Y/A1
+ VDD uio_in[2] VSS misr\[4\]_sg13g2_inv_1_A_Y_sg13g2_xnor2_1_A_B_sg13g2_o21ai_1_Y_A1_sg13g2_a21oi_1_Y/B1
+ sg13g2_nand2_1
Xbist_a\[7\]_sg13g2_dfrbpq_1_Q_D_sg13g2_o21ai_1_Y_A1_sg13g2_nand2_1_A_Y_sg13g2_a221oi_1_B2_C1_sg13g2_or2_1_X_A_sg13g2_nor4_1_Y
+ VSS VDD bist_a\[1\]_sg13g2_dfrbpq_1_Q_D_sg13g2_o21ai_1_Y/A1 bist_a\[0\]_sg13g2_dfrbpq_1_Q/Q
+ bist_a\[7\]_sg13g2_dfrbpq_1_Q_D_sg13g2_o21ai_1_Y_A1_sg13g2_nand2_1_A_Y_sg13g2_a221oi_1_B2_C1_sg13g2_or2_1_X/A
+ bist_a\[2\]_sg13g2_dfrbpq_1_Q_D_sg13g2_o21ai_1_Y/A1 bist_a\[7\]_sg13g2_or2_1_A/B
+ sg13g2_nor4_1
Xmisr\[1\]_sg13g2_a22oi_1_B2 uio_out_sg13g2_nand2_1_Y_3/B misr\[1\]_sg13g2_a22oi_1_B2/A2
+ VDD misr\[4\]_sg13g2_a22oi_1_B2/B1 misr\[1\]_sg13g2_a22oi_1_B2/A1 VSS misr\[1\]_sg13g2_inv_1_A/A
+ sg13g2_a22oi_1
Xscan_reg\[48\]_sg13g2_inv_1_A scan_reg\[48\]_sg13g2_inv_1_A/Y scan_reg\[48\]_sg13g2_inv_1_A/A
+ VSS VDD sg13g2_inv_1
Xbist_done_sg13g2_a22oi_1_B2_A2_sg13g2_and2_1_X bist_done_sg13g2_a22oi_1_B2/A2 VSS
+ VDD uio_in[7] uio_in[6] sg13g2_and2_1
Xbist_a\[7\]_sg13g2_dfrbpq_1_Q_D_sg13g2_o21ai_1_Y_A1_sg13g2_nand2_1_A_Y_sg13g2_a221oi_1_B2_Y_sg13g2_o21ai_1_B1_A2_sg13g2_nand2_1_Y
+ bist_a\[7\]_sg13g2_dfrbpq_1_Q_D_sg13g2_o21ai_1_Y_A1_sg13g2_nand2_1_A_Y_sg13g2_a221oi_1_B2_Y_sg13g2_o21ai_1_B1/A2
+ VDD bist_a\[7\]_sg13g2_dfrbpq_1_Q_D_sg13g2_o21ai_1_Y_A1_sg13g2_nand2_1_A_Y_sg13g2_a221oi_1_B2_Y_sg13g2_o21ai_1_B1_A2_sg13g2_nand2_1_Y/A
+ VSS misr\[1\]_sg13g2_inv_1_A_Y_sg13g2_xnor2_1_A_B_sg13g2_o21ai_1_Y_A2_sg13g2_nand3_1_Y_C_sg13g2_a22oi_1_Y/A1
+ sg13g2_nand2_1
Xscan_reg\[25\]_sg13g2_o21ai_1_A1 VSS VDD scan_reg\[25\]_sg13g2_o21ai_1_A1/Y scan_reg\[25\]_sg13g2_o21ai_1_A1/B1
+ scan_reg\[41\]_sg13g2_nor2_1_A/B scan_reg\[25\]_sg13g2_nor2_1_A/A sg13g2_o21ai_1
Xcycle_counter\[6\]_sg13g2_dfrbpq_1_Q VDD cycle_counter\[6\]_sg13g2_dfrbpq_1_Q/D cycle_counter\[6\]_sg13g2_dfrbpq_1_Q/Q
+ clkbuf_5_11__f_clk/X VSS rst_n sg13g2_dfrbpq_1
Xscan_reg\[33\]_sg13g2_dfrbpq_1_Q_D_sg13g2_o21ai_1_Y VSS VDD scan_reg\[33\]_sg13g2_dfrbpq_1_Q/D
+ scan_reg\[34\]_sg13g2_a22oi_1_B1/Y scan_reg\[41\]_sg13g2_nor2_1_A/B scan_reg\[33\]_sg13g2_inv_1_A/Y
+ sg13g2_o21ai_1
Xscan_reg\[51\]_sg13g2_o21ai_1_A1_B1_sg13g2_nand2b_1_Y VSS cycle_counter\[1\]_sg13g2_dfrbpq_1_Q/Q
+ scan_reg\[51\]_sg13g2_o21ai_1_A1/B1 ui_in[3] VDD sg13g2_nand2b_1
Xoverflow_flag_sg13g2_dfrbpq_1_Q_D_sg13g2_inv_1_Y_A_sg13g2_o21ai_1_Y_B1_sg13g2_nand3_1_Y_A_sg13g2_and4_1_A_X_sg13g2_nand3_1_B_C_sg13g2_a22oi_1_Y
+ overflow_flag_sg13g2_dfrbpq_1_Q_D_sg13g2_inv_1_Y_A_sg13g2_o21ai_1_Y_B1_sg13g2_nand3_1_Y_A_sg13g2_and4_1_A_X_sg13g2_nand3_1_B/C
+ overflow_flag_sg13g2_dfrbpq_1_Q_D_sg13g2_inv_1_Y_A_sg13g2_o21ai_1_Y_B1_sg13g2_nand3_1_Y_A_sg13g2_and4_1_A_X_sg13g2_nand3_1_B_C_sg13g2_a22oi_1_Y/A2
+ VDD overflow_flag_sg13g2_dfrbpq_1_Q_D_sg13g2_inv_1_Y_A_sg13g2_o21ai_1_Y_B1_sg13g2_nand3_1_Y_A_sg13g2_and4_1_A_X_sg13g2_nand3_1_B_C_sg13g2_a22oi_1_Y/B1
+ carry_flag_sg13g2_o21ai_1_A1_B1_sg13g2_nand2_1_Y_A_sg13g2_nand3_1_Y_A_sg13g2_a21oi_1_B1_Y_sg13g2_a22oi_1_B2/B1
+ VSS carry_flag_sg13g2_o21ai_1_A1_B1_sg13g2_nand2_1_Y_A_sg13g2_nand3_1_Y/C sg13g2_a22oi_1
Xscan_reg\[45\]_sg13g2_o21ai_1_A1 VSS VDD scan_reg\[45\]_sg13g2_o21ai_1_A1/Y scan_reg\[45\]_sg13g2_o21ai_1_A1/B1
+ scan_reg\[41\]_sg13g2_nor2_1_A/B scan_reg\[45\]_sg13g2_nor2_1_A/A sg13g2_o21ai_1
Xoperation\[3\]_sg13g2_dfrbpq_1_Q_D_sg13g2_a21oi_1_Y_A1_sg13g2_a21oi_1_A1_Y_sg13g2_nor2_1_B_Y_sg13g2_a21oi_1_B1_Y_sg13g2_nand3_1_A_Y_sg13g2_nor2_1_B_A_sg13g2_o21ai_1_Y_B1_sg13g2_o21ai_1_Y
+ VSS VDD operation\[3\]_sg13g2_dfrbpq_1_Q_D_sg13g2_a21oi_1_Y_A1_sg13g2_a21oi_1_A1_Y_sg13g2_nor2_1_B_Y_sg13g2_a21oi_1_B1_Y_sg13g2_nand3_1_A_Y_sg13g2_nor2_1_B_A_sg13g2_o21ai_1_Y/B1
+ serial_opcode\[2\]_sg13g2_nor3_1_A/Y serial_b\[0\]_sg13g2_xnor2_1_B/B serial_b\[0\]_sg13g2_xnor2_1_B/A
+ sg13g2_o21ai_1
Xbist_a\[7\]_sg13g2_dfrbpq_1_Q_D_sg13g2_o21ai_1_Y_A1_sg13g2_nand2_1_A_Y_sg13g2_a221oi_1_B2_A1_sg13g2_nor2b_1_Y
+ bist_a\[0\]_sg13g2_dfrbpq_1_Q/Q bist_a\[7\]_sg13g2_dfrbpq_1_Q_D_sg13g2_o21ai_1_Y_A1_sg13g2_o21ai_1_A1_Y_sg13g2_nand2b_1_A_N_B_sg13g2_a21oi_1_Y/A2
+ VDD bist_a\[7\]_sg13g2_dfrbpq_1_Q_D_sg13g2_o21ai_1_Y_A1_sg13g2_nand2_1_A_Y_sg13g2_a221oi_1_B2/A1
+ VSS sg13g2_nor2b_1
Xmisr\[4\]_sg13g2_inv_1_A misr\[4\]_sg13g2_inv_1_A/Y misr\[4\]_sg13g2_inv_1_A/A VSS
+ VDD sg13g2_inv_1
Xscan_reg\[14\]_sg13g2_dfrbpq_1_Q_D_sg13g2_a21oi_1_Y VDD VSS scan_out_sg13g2_a22oi_1_A1/A2
+ scan_reg\[14\]_sg13g2_inv_1_A/Y scan_reg\[15\]_sg13g2_o21ai_1_A1/Y scan_reg\[14\]_sg13g2_dfrbpq_1_Q/D
+ sg13g2_a21oi_1
Xoperand_a\[4\]_sg13g2_dfrbpq_1_Q VDD operand_a\[4\]_sg13g2_mux2_1_A0/X operand_a\[4\]_sg13g2_nor2b_1_A/A
+ clkload1/A VSS rst_n sg13g2_dfrbpq_1
Xscan_reg\[22\]_sg13g2_dfrbpq_1_Q_D_sg13g2_a221oi_1_Y_A2_sg13g2_inv_1_Y scan_reg\[22\]_sg13g2_dfrbpq_1_Q_D_sg13g2_a221oi_1_Y/A2
+ uo_out[2] VSS VDD sg13g2_inv_1
Xscan_reg\[34\]_sg13g2_inv_1_A scan_reg\[34\]_sg13g2_inv_1_A/Y scan_reg\[34\]_sg13g2_inv_1_A/A
+ VSS VDD sg13g2_inv_1
Xscan_reg\[54\]_sg13g2_dfrbpq_1_Q_D_sg13g2_a221oi_1_Y scan_reg\[55\]_sg13g2_nor2_1_A/Y
+ scan_reg\[54\]_sg13g2_dfrbpq_1_Q/D scan_out_sg13g2_a22oi_1_A1/A2 scan_reg\[54\]_sg13g2_inv_1_A/Y
+ ui_in[3] VDD scan_reg\[54\]_sg13g2_dfrbpq_1_Q_D_sg13g2_a221oi_1_Y/A1 VSS sg13g2_a221oi_1
Xuo_out_sg13g2_dfrbpq_1_Q_5_D_sg13g2_a21oi_1_Y_A2_sg13g2_o21ai_1_Y_B1_sg13g2_or2_1_X_B_sg13g2_nand2_1_Y_A_sg13g2_a221oi_1_Y_C1_sg13g2_nand4_1_Y_D_sg13g2_a21oi_1_Y
+ VDD VSS serial_opcode\[0\]_sg13g2_o21ai_1_A1/Y serial_b\[6\]_sg13g2_and2_1_A/B uo_out_sg13g2_dfrbpq_1_Q_5_D_sg13g2_a21oi_1_Y_A2_sg13g2_o21ai_1_Y_B1_sg13g2_or2_1_X_B_sg13g2_nand2_1_Y_A_sg13g2_a221oi_1_Y_C1_sg13g2_nand4_1_Y_D_sg13g2_a21oi_1_Y/B1
+ uo_out_sg13g2_dfrbpq_1_Q_5_D_sg13g2_a21oi_1_Y_A2_sg13g2_o21ai_1_Y_B1_sg13g2_or2_1_X_B_sg13g2_nand2_1_Y_A_sg13g2_a221oi_1_Y_C1_sg13g2_nand4_1_Y/D
+ sg13g2_a21oi_1
Xbist_a\[4\]_sg13g2_dfrbpq_1_Q_D_sg13g2_mux2_1_X lfsr\[4\]_sg13g2_dfrbpq_1_Q/Q bist_a\[4\]_sg13g2_dfrbpq_1_Q/D
+ lfsr\[7\]_sg13g2_nand2_1_A/B VDD VSS bist_a\[4\]_sg13g2_dfrbpq_1_Q/Q sg13g2_mux2_1
Xcarry_flag_sg13g2_o21ai_1_A1_B1_sg13g2_nand2_1_Y_A_sg13g2_nand3_1_Y_B_sg13g2_nand3_1_C_A_sg13g2_o21ai_1_B1_A1_sg13g2_nor2b_1_Y
+ serial_a\[7\]_sg13g2_dfrbpq_1_Q/Q serial_b\[7\]_sg13g2_dfrbpq_1_Q/Q VDD carry_flag_sg13g2_o21ai_1_A1_B1_sg13g2_nand2_1_Y_A_sg13g2_nand3_1_Y_B_sg13g2_nand3_1_C_A_sg13g2_o21ai_1_B1/A1
+ VSS sg13g2_nor2b_1
Xscan_reg\[1\]_sg13g2_dfrbpq_1_Q VDD scan_reg\[1\]_sg13g2_dfrbpq_1_Q/D scan_reg\[1\]_sg13g2_dfrbpq_1_Q/Q
+ clkbuf_5_6__f_clk/X VSS rst_n sg13g2_dfrbpq_1
Xscan_reg\[20\]_sg13g2_inv_1_A scan_reg\[20\]_sg13g2_inv_1_A/Y scan_reg\[20\]_sg13g2_inv_1_A/A
+ VSS VDD sg13g2_inv_1
Xoverflow_flag_sg13g2_dfrbpq_1_Q_D_sg13g2_inv_1_Y_A_sg13g2_o21ai_1_Y_B1_sg13g2_nand3_1_Y_A_sg13g2_nand2_1_Y_B_sg13g2_a21oi_1_Y_A2_sg13g2_o21ai_1_Y_B1_sg13g2_and2_1_X_B_sg13g2_nand2_1_B
+ carry_flag_sg13g2_o21ai_1_A1_B1_sg13g2_nand2_1_Y_A_sg13g2_nand3_1_Y_B_sg13g2_nand3_1_C_Y_sg13g2_o21ai_1_B1_A2_sg13g2_nor3_1_Y_C_sg13g2_nor4_1_Y_D_sg13g2_nand2_1_Y/A
+ VDD serial_b\[6\]_sg13g2_nand2_1_A/Y VSS overflow_flag_sg13g2_dfrbpq_1_Q_D_sg13g2_inv_1_Y_A_sg13g2_o21ai_1_Y_B1_sg13g2_nand3_1_Y_A_sg13g2_nand2_1_Y_B_sg13g2_a21oi_1_Y_A2_sg13g2_o21ai_1_Y_B1_sg13g2_and2_1_X/B
+ sg13g2_nand2_1
Xscan_out_sg13g2_a22oi_1_A1 scan_out_sg13g2_a22oi_1_A1/Y scan_out_sg13g2_a22oi_1_A1/A2
+ VDD scan_out_sg13g2_a22oi_1_A1/B1 scan_out_sg13g2_dfrbpq_1_Q/Q VSS scan_out_sg13g2_a22oi_1_A1/B2
+ sg13g2_a22oi_1
Xbist_a\[3\]_sg13g2_dfrbpq_1_Q_D_sg13g2_o21ai_1_Y VSS VDD bist_a\[3\]_sg13g2_dfrbpq_1_Q/D
+ bist_a\[3\]_sg13g2_dfrbpq_1_Q_D_sg13g2_o21ai_1_Y/B1 lfsr\[7\]_sg13g2_nand2_1_A/B
+ bist_a\[3\]_sg13g2_dfrbpq_1_Q_D_sg13g2_o21ai_1_Y/A1 sg13g2_o21ai_1
Xcarry_flag_sg13g2_o21ai_1_A1_B1_sg13g2_nand2_1_Y_A_sg13g2_nand3_1_Y_A_sg13g2_a21oi_1_B1_Y_sg13g2_a221oi_1_B2
+ carry_flag_sg13g2_o21ai_1_A1_B1_sg13g2_nand2_1_Y_A_sg13g2_nand3_1_Y_A_sg13g2_a21oi_1_B1_Y_sg13g2_a221oi_1_B2/C1
+ carry_flag_sg13g2_o21ai_1_A1_B1_sg13g2_nand2_1_Y_A_sg13g2_nand3_1_Y_A_sg13g2_a21oi_1_B1_Y_sg13g2_a221oi_1_B2/Y
+ carry_flag_sg13g2_o21ai_1_A1_B1_sg13g2_nand2_1_Y_A_sg13g2_nand3_1_Y_A_sg13g2_a21oi_1_B1/Y
+ carry_flag_sg13g2_o21ai_1_A1_B1_sg13g2_nand2_1_Y_A_sg13g2_nand3_1_Y_A_sg13g2_a21oi_1_B1_Y_sg13g2_a22oi_1_B2/B1
+ overflow_flag_sg13g2_dfrbpq_1_Q_D_sg13g2_inv_1_Y_A_sg13g2_o21ai_1_Y_B1_sg13g2_nand3_1_Y_A_sg13g2_nand2_1_Y/B
+ VDD carry_flag_sg13g2_o21ai_1_A1_B1_sg13g2_nand2_1_Y_A_sg13g2_nand3_1_Y_A_sg13g2_a21oi_1_B1_Y_sg13g2_a22oi_1_B2/A1
+ VSS sg13g2_a221oi_1
Xfault_counter\[3\]_sg13g2_dfrbpq_1_Q VDD fault_counter\[3\]_sg13g2_dfrbpq_1_Q/D fault_counter\[3\]_sg13g2_dfrbpq_1_Q/Q
+ clkbuf_5_11__f_clk/X VSS rst_n sg13g2_dfrbpq_1
Xuo_out_sg13g2_dfrbpq_1_Q_2_D_sg13g2_o21ai_1_Y_B1_sg13g2_nand3_1_Y_C_sg13g2_nand3_1_Y
+ VDD uo_out_sg13g2_dfrbpq_1_Q_2_D_sg13g2_o21ai_1_Y_B1_sg13g2_nand3_1_Y/C uo_out_sg13g2_dfrbpq_1_Q_2_D_sg13g2_o21ai_1_Y_B1_sg13g2_nand3_1_Y_C_sg13g2_nand3_1_Y/B
+ uo_out_sg13g2_dfrbpq_1_Q_2_D_sg13g2_o21ai_1_Y_B1_sg13g2_nand3_1_Y_C_sg13g2_nand3_1_Y/C
+ uo_out_sg13g2_dfrbpq_1_Q_2_D_sg13g2_o21ai_1_Y_B1_sg13g2_nand3_1_Y_C_sg13g2_nand3_1_Y/A
+ VSS sg13g2_nand3_1
Xbist_a\[7\]_sg13g2_dfrbpq_1_Q_D_sg13g2_o21ai_1_Y_A1_sg13g2_nand2_1_A_Y_sg13g2_a221oi_1_B2_Y_sg13g2_o21ai_1_B1_A1_sg13g2_nor3_1_Y_B_sg13g2_nor2_1_Y
+ bist_a\[2\]_sg13g2_dfrbpq_1_Q_D_sg13g2_o21ai_1_Y/A1 VDD bist_a\[7\]_sg13g2_dfrbpq_1_Q_D_sg13g2_o21ai_1_Y_A1_sg13g2_nand2_1_A_Y_sg13g2_a221oi_1_B2_Y_sg13g2_o21ai_1_B1_A1_sg13g2_nor3_1_Y/B
+ VSS lfsr\[6\]_sg13g2_mux2_1_A1/A0 sg13g2_nor2_1
Xscan_reg\[39\]_sg13g2_inv_1_A scan_reg\[39\]_sg13g2_inv_1_A/Y scan_reg\[39\]_sg13g2_inv_1_A/A
+ VSS VDD sg13g2_inv_1
Xuo_out_sg13g2_dfrbpq_1_Q_5_D_sg13g2_a21oi_1_Y_A2_sg13g2_o21ai_1_Y_B1_sg13g2_or2_1_X_B_sg13g2_nand2_1_Y_A_sg13g2_a221oi_1_Y_C1_sg13g2_nand4_1_Y_D_sg13g2_a21oi_1_Y_B1_sg13g2_nor2_1_Y
+ serial_a\[5\]_sg13g2_dfrbpq_1_Q/Q VDD uo_out_sg13g2_dfrbpq_1_Q_5_D_sg13g2_a21oi_1_Y_A2_sg13g2_o21ai_1_Y_B1_sg13g2_or2_1_X_B_sg13g2_nand2_1_Y_A_sg13g2_a221oi_1_Y_C1_sg13g2_nand4_1_Y_D_sg13g2_a21oi_1_Y/B1
+ VSS overflow_flag_sg13g2_dfrbpq_1_Q_D_sg13g2_inv_1_Y_A_sg13g2_o21ai_1_Y_B1_sg13g2_nand3_1_Y_A_sg13g2_and4_1_A_B_sg13g2_or2_1_X/B
+ sg13g2_nor2_1
Xmisr\[1\]_sg13g2_inv_1_A_Y_sg13g2_xnor2_1_A_B_sg13g2_o21ai_1_Y_A2_sg13g2_nand3_1_Y_C_sg13g2_a22oi_1_Y_A2_sg13g2_xnor2_1_Y_A_sg13g2_o21ai_1_A1
+ VSS VDD bist_a\[7\]_sg13g2_dfrbpq_1_Q_D_sg13g2_o21ai_1_Y_A1_sg13g2_nand2_1_A_Y_sg13g2_a221oi_1_A1_Y_sg13g2_o21ai_1_B1_A1_sg13g2_xnor2_1_Y/B
+ misr\[1\]_sg13g2_inv_1_A_Y_sg13g2_xnor2_1_A_B_sg13g2_o21ai_1_Y_A2_sg13g2_nand3_1_Y_C_sg13g2_a22oi_1_Y_A2_sg13g2_xnor2_1_Y_A_sg13g2_o21ai_1_A1/B1
+ misr\[6\]_sg13g2_dfrbpq_1_Q_D_sg13g2_o21ai_1_Y_A2_sg13g2_xnor2_1_Y_B_sg13g2_a22oi_1_Y_A1_sg13g2_and4_1_X_A_sg13g2_nand2_1_Y_B_sg13g2_xnor2_1_Y/B
+ misr\[1\]_sg13g2_inv_1_A_Y_sg13g2_xnor2_1_A_B_sg13g2_o21ai_1_Y_A2_sg13g2_nand3_1_Y_C_sg13g2_a22oi_1_Y_A2_sg13g2_xnor2_1_Y/A
+ sg13g2_o21ai_1
Xuo_out_sg13g2_dfrbpq_1_Q_6_D_sg13g2_a21oi_1_Y_A2_sg13g2_a21o_1_X_A2_sg13g2_and2_1_X_A_sg13g2_a221oi_1_Y_B2_sg13g2_and2_1_X
+ uo_out_sg13g2_dfrbpq_1_Q_6_D_sg13g2_a21oi_1_Y_A2_sg13g2_a21o_1_X_A2_sg13g2_and2_1_X_A_sg13g2_a221oi_1_Y/B2
+ VSS VDD uo_out_sg13g2_dfrbpq_1_Q_6_D_sg13g2_a21oi_1_Y_A2_sg13g2_a21o_1_X_A2_sg13g2_and2_1_X_A_sg13g2_a221oi_1_Y_B2_sg13g2_and2_1_X/B
+ uo_out_sg13g2_dfrbpq_1_Q_6_D_sg13g2_a21oi_1_Y_A2_sg13g2_a21o_1_X_A2_sg13g2_and2_1_X_A_sg13g2_a221oi_1_Y_B2_sg13g2_and2_1_X/A
+ sg13g2_and2_1
Xmisr\[1\]_sg13g2_inv_1_A_Y_sg13g2_xnor2_1_A_B_sg13g2_o21ai_1_Y_A2_sg13g2_nand3_1_Y_C_sg13g2_a22oi_1_Y_B1_sg13g2_and2_1_X_A_sg13g2_or3_1_X_C_sg13g2_a22oi_1_Y
+ misr\[1\]_sg13g2_inv_1_A_Y_sg13g2_xnor2_1_A_B_sg13g2_o21ai_1_Y_A2_sg13g2_nand3_1_Y_C_sg13g2_a22oi_1_Y_B1_sg13g2_and2_1_X_A_sg13g2_or3_1_X/C
+ bist_a\[5\]_sg13g2_dfrbpq_1_Q/Q VDD bist_a\[0\]_sg13g2_dfrbpq_1_Q/Q bist_a\[1\]_sg13g2_dfrbpq_1_Q/Q
+ VSS bist_a\[4\]_sg13g2_dfrbpq_1_Q/Q sg13g2_a22oi_1
Xserial_a\[3\]_sg13g2_dfrbpq_1_Q VDD serial_a\[3\]_sg13g2_dfrbpq_1_Q/D serial_a\[3\]_sg13g2_dfrbpq_1_Q/Q
+ clkload1/A VSS rst_n sg13g2_dfrbpq_1
Xmisr\[4\]_sg13g2_inv_1_A_Y_sg13g2_xnor2_1_A_B_sg13g2_o21ai_1_Y_A1_sg13g2_a21oi_1_Y_A2_sg13g2_a21oi_1_Y_A1_sg13g2_nor2b_1_Y_A_sg13g2_nand2_1_Y
+ misr\[4\]_sg13g2_inv_1_A_Y_sg13g2_xnor2_1_A_B_sg13g2_o21ai_1_Y_A1_sg13g2_a21oi_1_Y_A2_sg13g2_a21oi_1_Y_A1_sg13g2_nor2b_1_Y/A
+ VDD bist_a\[2\]_sg13g2_dfrbpq_1_Q/Q VSS bist_a\[7\]_sg13g2_or2_1_A/B sg13g2_nand2_1
Xoperand_a\[5\]_sg13g2_nand2b_1_A_N VSS operand_a\[5\]_sg13g2_mux2_1_A0/A0 scan_reg\[6\]_sg13g2_o21ai_1_A1/B1
+ ui_in[3] VDD sg13g2_nand2b_1
Xoperand_b\[7\]_sg13g2_dfrbpq_1_Q VDD operand_b\[7\]_sg13g2_mux2_1_A0/X operand_b\[7\]_sg13g2_mux2_1_A0/A0
+ clkbuf_5_20__f_clk/X VSS rst_n sg13g2_dfrbpq_1
Xmisr\[1\]_sg13g2_dfrbpq_1_Q_D_sg13g2_a22oi_1_Y_B2_sg13g2_o21ai_1_Y_A2_sg13g2_a22oi_1_Y_A2_sg13g2_and2_1_X_B_sg13g2_a22oi_1_Y
+ misr\[1\]_sg13g2_dfrbpq_1_Q_D_sg13g2_a22oi_1_Y_B2_sg13g2_o21ai_1_Y_A2_sg13g2_a22oi_1_Y_A2_sg13g2_and2_1_X/B
+ misr\[4\]_sg13g2_inv_1_A_Y_sg13g2_xnor2_1_A_B_sg13g2_o21ai_1_Y_B1_sg13g2_or2_1_X_A_sg13g2_nand3_1_Y_B_sg13g2_a22oi_1_Y/A2
+ VDD misr\[4\]_sg13g2_inv_1_A_Y_sg13g2_xnor2_1_A_B_sg13g2_o21ai_1_Y_B1_sg13g2_or2_1_X_A_sg13g2_nand3_1_Y_B_sg13g2_a22oi_1_Y/B1
+ misr\[4\]_sg13g2_inv_1_A_Y_sg13g2_xnor2_1_A_B_sg13g2_o21ai_1_Y_A1_sg13g2_a21oi_1_Y_A2_sg13g2_a21oi_1_Y/A1
+ VSS bist_a\[7\]_sg13g2_dfrbpq_1_Q_D_sg13g2_o21ai_1_Y_A1_sg13g2_nand2_1_A_Y_sg13g2_a221oi_1_A1/C1
+ sg13g2_a22oi_1
Xbist_state\[1\]_sg13g2_dfrbpq_1_Q VDD lfsr\[7\]_sg13g2_nand2_1_A/B bist_state\[1\]_sg13g2_inv_1_A/A
+ clkbuf_5_6__f_clk/X VSS rst_n sg13g2_dfrbpq_1
Xoverflow_flag_sg13g2_dfrbpq_1_Q_D_sg13g2_inv_1_Y_A_sg13g2_o21ai_1_Y_B1_sg13g2_nand3_1_Y_A_sg13g2_and4_1_A_X_sg13g2_nand3_1_B_C_sg13g2_a22oi_1_Y_B1_sg13g2_xor2_1_X_A_sg13g2_nand2_1_Y
+ overflow_flag_sg13g2_dfrbpq_1_Q_D_sg13g2_inv_1_Y_A_sg13g2_o21ai_1_Y_B1_sg13g2_nand3_1_Y_A_sg13g2_and4_1_A_X_sg13g2_nand3_1_B_C_sg13g2_a22oi_1_Y_B1_sg13g2_xor2_1_X/A
+ VDD serial_b\[6\]_sg13g2_nand2b_1_A_N/Y VSS carry_flag_sg13g2_o21ai_1_A1_B1_sg13g2_nand2_1_Y_A_sg13g2_nand3_1_Y_B_sg13g2_nand3_1_Y/C
+ sg13g2_nand2_1
Xbist_a\[2\]_sg13g2_dfrbpq_1_Q VDD bist_a\[2\]_sg13g2_dfrbpq_1_Q/D bist_a\[2\]_sg13g2_dfrbpq_1_Q/Q
+ clkbuf_5_0__f_clk/X VSS rst_n sg13g2_dfrbpq_1
Xbist_done_sg13g2_dfrbpq_1_Q_D_sg13g2_o21ai_1_Y_A2_sg13g2_nor2b_1_Y bist_state\[1\]_sg13g2_a21oi_1_A1/A2
+ ui_in[7] VDD bist_state\[1\]_sg13g2_a21oi_1_A1/B1 VSS sg13g2_nor2b_1
Xscan_reg\[27\]_sg13g2_dfrbpq_1_Q_D_sg13g2_o21ai_1_Y_A1_sg13g2_inv_1_Y scan_reg\[27\]_sg13g2_dfrbpq_1_Q_D_sg13g2_o21ai_1_Y/A1
+ ui_in[6] VSS VDD sg13g2_inv_1
Xuo_out_sg13g2_dfrbpq_1_Q_2_D_sg13g2_o21ai_1_Y_B1_sg13g2_nand3_1_Y_C_sg13g2_nand3_1_Y_B_sg13g2_or2_1_X
+ uo_out_sg13g2_dfrbpq_1_Q_2_D_sg13g2_o21ai_1_Y_B1_sg13g2_nand3_1_Y_B_sg13g2_nand2_1_Y/A
+ VSS uo_out_sg13g2_dfrbpq_1_Q_2_D_sg13g2_o21ai_1_Y_B1_sg13g2_nand3_1_Y_C_sg13g2_nand3_1_Y_B_sg13g2_or2_1_X/B
+ uo_out_sg13g2_dfrbpq_1_Q_2_D_sg13g2_o21ai_1_Y_B1_sg13g2_nand3_1_Y_C_sg13g2_nand3_1_Y/B
+ VDD sg13g2_or2_1
Xclkbuf_5_0__f_clk clkbuf_5_0__f_clk/X VSS clkbuf_4_0_0_clk/X VDD sg13g2_buf_4
Xuo_out_sg13g2_dfrbpq_1_Q_6_D_sg13g2_a21oi_1_Y_A2_sg13g2_a21o_1_X_A2_sg13g2_and2_1_X_B_sg13g2_a22oi_1_Y_B2_sg13g2_and2_1_X_B_sg13g2_o21ai_1_Y_A2_sg13g2_or3_1_C
+ VDD VSS uo_out_sg13g2_dfrbpq_1_Q_6_D_sg13g2_a21oi_1_Y_A2_sg13g2_a21o_1_X_A2_sg13g2_and2_1_X_B_sg13g2_a22oi_1_Y_B2_sg13g2_and2_1_X_B_sg13g2_o21ai_1_Y/A2
+ carry_flag_sg13g2_o21ai_1_A1_B1_sg13g2_nand2_1_Y_A_sg13g2_nand3_1_Y_A_sg13g2_a21oi_1_B1_Y_sg13g2_a221oi_1_B2_C1_sg13g2_o21ai_1_Y/A1
+ uo_out_sg13g2_dfrbpq_1_Q_6_D_sg13g2_a21oi_1_Y_A2_sg13g2_a21o_1_X_A2_sg13g2_and2_1_X_B_sg13g2_a22oi_1_Y_B2_sg13g2_and2_1_X_B_sg13g2_o21ai_1_Y/B1
+ uo_out_sg13g2_dfrbpq_1_Q_6_D_sg13g2_a21oi_1_Y_A2_sg13g2_a21o_1_X_A2_sg13g2_and2_1_X_B_sg13g2_a22oi_1_Y_B2_sg13g2_and2_1_X/A
+ sg13g2_or3_1
Xbist_pattern_count\[0\]_sg13g2_dfrbpq_1_Q_D_sg13g2_a21oi_1_Y VDD VSS bist_pattern_count\[1\]_sg13g2_and3_1_A/C
+ bist_pattern_count\[1\]_sg13g2_and3_1_A/B bist_pattern_count\[0\]_sg13g2_dfrbpq_1_Q_D_sg13g2_a21oi_1_Y/B1
+ bist_pattern_count\[0\]_sg13g2_dfrbpq_1_Q/D sg13g2_a21oi_1
Xscan_reg\[45\]_sg13g2_dfrbpq_1_Q_D_sg13g2_a21oi_1_Y VDD VSS scan_out_sg13g2_a22oi_1_A1/B1
+ scan_reg\[46\]_sg13g2_inv_1_A/Y scan_reg\[45\]_sg13g2_o21ai_1_A1/Y scan_reg\[45\]_sg13g2_dfrbpq_1_Q/D
+ sg13g2_a21oi_1
Xmisr\[4\]_sg13g2_inv_1_A_Y_sg13g2_xnor2_1_A_B_sg13g2_o21ai_1_Y_A1_sg13g2_a21oi_1_Y_A2_sg13g2_a21oi_1_Y_B1_sg13g2_o21ai_1_Y_A2_sg13g2_xnor2_1_Y
+ misr\[4\]_sg13g2_inv_1_A_Y_sg13g2_xnor2_1_A_B_sg13g2_o21ai_1_Y_A1_sg13g2_a21oi_1_Y_A2_sg13g2_a21oi_1_Y_B1_sg13g2_o21ai_1_Y/A2
+ bist_a\[7\]_sg13g2_dfrbpq_1_Q_D_sg13g2_o21ai_1_Y_A1_sg13g2_o21ai_1_A1_Y_sg13g2_nand2b_1_A_N_Y_sg13g2_a221oi_1_C1_B1_sg13g2_mux2_1_X/S
+ VDD bist_a\[4\]_sg13g2_dfrbpq_1_Q/Q VSS sg13g2_xnor2_1
Xscan_reg\[22\]_sg13g2_dfrbpq_1_Q VDD scan_reg\[22\]_sg13g2_dfrbpq_1_Q/D scan_reg\[22\]_sg13g2_inv_1_A/A
+ clkbuf_5_30__f_clk/X VSS rst_n sg13g2_dfrbpq_1
Xbist_pattern_count\[6\]_sg13g2_a21oi_1_B1 VDD VSS bist_pattern_count\[4\]_sg13g2_and2_1_A/X
+ bist_pattern_count\[6\]_sg13g2_nand3_1_C/B bist_pattern_count\[6\]_sg13g2_nand3_1_C/C
+ bist_pattern_count\[6\]_sg13g2_a21oi_1_B1/Y sg13g2_a21oi_1
Xbist_a\[7\]_sg13g2_dfrbpq_1_Q_D_sg13g2_o21ai_1_Y_A1_sg13g2_nand2_1_A_Y_sg13g2_a221oi_1_A1_A2_sg13g2_nand3_1_Y_B_sg13g2_nand2b_1_Y
+ VSS bist_a\[7\]_sg13g2_dfrbpq_1_Q_D_sg13g2_o21ai_1_Y_A1_sg13g2_nand2_1_A_Y_sg13g2_a221oi_1_A1_A2_sg13g2_nand3_1_Y_C_sg13g2_nand3_1_Y/C
+ bist_a\[7\]_sg13g2_dfrbpq_1_Q_D_sg13g2_o21ai_1_Y_A1_sg13g2_nand2_1_A_Y_sg13g2_a221oi_1_A1_A2_sg13g2_nand3_1_Y/B
+ bist_a\[7\]_sg13g2_dfrbpq_1_Q_D_sg13g2_o21ai_1_Y_A1_sg13g2_o21ai_1_A1_B1_sg13g2_a21oi_1_Y_A2_sg13g2_and2_1_X/B
+ VDD sg13g2_nand2b_1
Xscan_reg\[48\]_sg13g2_dfrbpq_1_Q_D_sg13g2_a221oi_1_Y scan_reg\[49\]_sg13g2_nor2_1_A/Y
+ scan_reg\[48\]_sg13g2_dfrbpq_1_Q/D scan_out_sg13g2_a22oi_1_A1/A2 scan_reg\[48\]_sg13g2_inv_1_A/Y
+ scan_reg\[48\]_sg13g2_dfrbpq_1_Q_D_sg13g2_a221oi_1_Y/A2 VDD ui_in[3] VSS sg13g2_a221oi_1
Xmisr\[1\]_sg13g2_inv_1_A_Y_sg13g2_xnor2_1_A_B_sg13g2_o21ai_1_Y_A2_sg13g2_nand3_1_Y_C_sg13g2_a22oi_1_Y_A2_sg13g2_xnor2_1_Y_B_sg13g2_inv_1_A_Y_sg13g2_a21oi_1_B1
+ VDD VSS misr\[4\]_sg13g2_inv_1_A_Y_sg13g2_xnor2_1_A_B_sg13g2_o21ai_1_Y_B1_sg13g2_or2_1_X_A_sg13g2_nand3_1_Y_C_sg13g2_a21oi_1_Y_B1_sg13g2_a221oi_1_Y/A2
+ bist_a\[7\]_sg13g2_dfrbpq_1_Q_D_sg13g2_o21ai_1_Y_A1_sg13g2_o21ai_1_A1_Y_sg13g2_nand2b_1_A_N_Y_sg13g2_a221oi_1_C1_B1_sg13g2_mux2_1_X/S
+ misr\[1\]_sg13g2_inv_1_A_Y_sg13g2_xnor2_1_A_B_sg13g2_o21ai_1_Y_A2_sg13g2_nand3_1_Y_C_sg13g2_a22oi_1_Y_A2_sg13g2_xnor2_1_Y_B_sg13g2_inv_1_A/Y
+ misr\[6\]_sg13g2_dfrbpq_1_Q_D_sg13g2_o21ai_1_Y_A2_sg13g2_xnor2_1_Y_B_sg13g2_a22oi_1_Y_A1_sg13g2_and4_1_X_A_sg13g2_nand2_1_Y_B_sg13g2_xnor2_1_Y/B
+ sg13g2_a21oi_1
Xscan_reg\[42\]_sg13g2_dfrbpq_1_Q VDD scan_reg\[42\]_sg13g2_dfrbpq_1_Q/D scan_reg\[42\]_sg13g2_inv_1_A/A
+ clkbuf_5_8__f_clk/X VSS rst_n sg13g2_dfrbpq_1
Xlfsr\[1\]_sg13g2_nand2_1_A lfsr\[1\]_sg13g2_nand2_1_A/Y VDD lfsr\[1\]_sg13g2_nand2_1_A/A
+ VSS lfsr\[7\]_sg13g2_nand2_1_A/B sg13g2_nand2_1
Xmisr\[1\]_sg13g2_inv_1_A_Y_sg13g2_xnor2_1_A_B_sg13g2_o21ai_1_Y_A2_sg13g2_nand3_1_Y_B_sg13g2_nor3_1_Y_A_sg13g2_nor2_1_Y_B_sg13g2_or2_1_B
+ bist_a\[0\]_sg13g2_dfrbpq_1_Q/Q VSS misr\[1\]_sg13g2_inv_1_A_Y_sg13g2_xnor2_1_A_B_sg13g2_o21ai_1_Y_A2_sg13g2_nand3_1_Y_B_sg13g2_nor3_1_Y_A_sg13g2_nor2_1_Y/B
+ bist_a\[7\]_sg13g2_dfrbpq_1_Q_D_sg13g2_o21ai_1_Y_A1_sg13g2_o21ai_1_A1_Y_sg13g2_nand2b_1_A_N_B_sg13g2_a21oi_1_Y_B1_sg13g2_a21oi_1_Y/A2
+ VDD sg13g2_or2_1
Xcycle_counter\[1\]_sg13g2_dfrbpq_1_Q_D_sg13g2_xor2_1_X cycle_counter\[1\]_sg13g2_dfrbpq_1_Q/D
+ VDD cycle_counter\[1\]_sg13g2_dfrbpq_1_Q/Q cycle_counter\[0\]_sg13g2_dfrbpq_1_Q/Q
+ VSS sg13g2_xor2_1
Xserial_b\[6\]_sg13g2_dfrbpq_1_Q VDD serial_b\[6\]_sg13g2_dfrbpq_1_Q/D serial_b\[6\]_sg13g2_and2_1_A/A
+ clkbuf_5_21__f_clk/X VSS rst_n sg13g2_dfrbpq_1
Xuo_out_sg13g2_dfrbpq_1_Q_2_D_sg13g2_o21ai_1_Y_B1_sg13g2_nand3_1_Y VDD uo_out_sg13g2_dfrbpq_1_Q_2_D_sg13g2_o21ai_1_Y/B1
+ uo_out_sg13g2_dfrbpq_1_Q_2_D_sg13g2_o21ai_1_Y_B1_sg13g2_nand3_1_Y/B uo_out_sg13g2_dfrbpq_1_Q_2_D_sg13g2_o21ai_1_Y_B1_sg13g2_nand3_1_Y/C
+ ui_in[2] VSS sg13g2_nand3_1
Xscan_reg\[16\]_sg13g2_inv_1_A scan_reg\[16\]_sg13g2_inv_1_A/Y scan_reg\[16\]_sg13g2_inv_1_A/A
+ VSS VDD sg13g2_inv_1
Xbist_pattern_count\[1\]_sg13g2_dfrbpq_1_Q VDD bist_pattern_count\[1\]_sg13g2_dfrbpq_1_Q/D
+ bist_pattern_count\[1\]_sg13g2_and3_1_A/A clkbuf_5_4__f_clk/X VSS rst_n sg13g2_dfrbpq_1
Xbist_a\[7\]_sg13g2_or2_1_A bist_a\[7\]_sg13g2_or2_1_A/A VSS bist_a\[7\]_sg13g2_or2_1_A/B
+ bist_a\[7\]_sg13g2_or2_1_A/X VDD sg13g2_or2_1
Xoverflow_flag_sg13g2_dfrbpq_1_Q_D_sg13g2_inv_1_Y_A_sg13g2_o21ai_1_Y_B1_sg13g2_nand3_1_Y_C_sg13g2_a21oi_1_Y_A1_sg13g2_o21ai_1_A2_B1_sg13g2_o21ai_1_A1_Y_sg13g2_nor2_1_B_Y_sg13g2_o21ai_1_B1
+ VSS VDD carry_flag_sg13g2_o21ai_1_A1_B1_sg13g2_nand2_1_Y_B_sg13g2_a21oi_1_Y_A2_sg13g2_a21oi_1_Y_B1_sg13g2_o21ai_1_B1_Y_sg13g2_a221oi_1_B1_1_Y_sg13g2_or4_1_C/D
+ overflow_flag_sg13g2_dfrbpq_1_Q_D_sg13g2_inv_1_Y_A_sg13g2_o21ai_1_Y_B1_sg13g2_nand3_1_Y_C_sg13g2_a21oi_1_Y_A1_sg13g2_o21ai_1_A2_B1_sg13g2_o21ai_1_A1_Y_sg13g2_nor2_1_B/Y
+ carry_flag_sg13g2_o21ai_1_A1_B1_sg13g2_nand2_1_Y_B_sg13g2_a21oi_1_Y_A2_sg13g2_a21oi_1_Y_B1_sg13g2_o21ai_1_B1_Y_sg13g2_a221oi_1_B1_1_Y_sg13g2_or4_1_C_B_sg13g2_nor3_1_Y/C
+ overflow_flag_sg13g2_dfrbpq_1_Q_D_sg13g2_inv_1_Y_A_sg13g2_o21ai_1_Y_B1_sg13g2_nand3_1_Y_C_sg13g2_a21oi_1_Y_A1_sg13g2_o21ai_1_A2_B1_sg13g2_o21ai_1_A1_Y_sg13g2_nor2_1_B_Y_sg13g2_o21ai_1_B1/A1
+ sg13g2_o21ai_1
Xoperand_a\[4\]_sg13g2_mux2_1_A0 serial_b\[4\]_sg13g2_nand2_1_A/B operand_a\[4\]_sg13g2_mux2_1_A0/X
+ ui_in[2] VDD VSS operand_a\[4\]_sg13g2_nor2b_1_A/A sg13g2_mux2_1
Xmisr\[6\]_sg13g2_dfrbpq_1_Q_D_sg13g2_o21ai_1_Y_A2_sg13g2_xnor2_1_Y_B_sg13g2_a22oi_1_Y_A1_sg13g2_and4_1_X_D_sg13g2_a221oi_1_Y_C1_sg13g2_a21oi_1_Y
+ VDD VSS bist_a\[3\]_sg13g2_dfrbpq_1_Q_D_sg13g2_o21ai_1_Y/A1 lfsr\[6\]_sg13g2_mux2_1_A1/A0
+ bist_a\[7\]_sg13g2_dfrbpq_1_Q_D_sg13g2_o21ai_1_Y_A1_sg13g2_nand2_1_A_Y_sg13g2_a221oi_1_B2_B1_sg13g2_nand2_1_Y/A
+ misr\[6\]_sg13g2_dfrbpq_1_Q_D_sg13g2_o21ai_1_Y_A2_sg13g2_xnor2_1_Y_B_sg13g2_a22oi_1_Y_A1_sg13g2_and4_1_X_D_sg13g2_a221oi_1_Y/C1
+ sg13g2_a21oi_1
Xclkbuf_5_19__f_clk clkbuf_5_19__f_clk/X VSS clkbuf_4_9_0_clk/X VDD sg13g2_buf_4
Xscan_reg\[55\]_sg13g2_nor2_1_A scan_reg\[55\]_sg13g2_nor2_1_A/A VDD scan_reg\[55\]_sg13g2_nor2_1_A/Y
+ VSS scan_reg\[3\]_sg13g2_nor2_1_A/B sg13g2_nor2_1
Xscan_reg\[34\]_sg13g2_dfrbpq_1_Q_D_sg13g2_o21ai_1_Y VSS VDD scan_reg\[34\]_sg13g2_dfrbpq_1_Q/D
+ scan_reg\[35\]_sg13g2_a22oi_1_B1/Y scan_reg\[41\]_sg13g2_nor2_1_A/B scan_reg\[34\]_sg13g2_inv_1_A/Y
+ sg13g2_o21ai_1
Xoverflow_flag_sg13g2_dfrbpq_1_Q_D_sg13g2_inv_1_Y_A_sg13g2_o21ai_1_Y_B1_sg13g2_nand3_1_Y_C_sg13g2_a21oi_1_Y_A1_sg13g2_o21ai_1_A2_B1_sg13g2_o21ai_1_A1_Y_sg13g2_nor2_1_B_A_sg13g2_nand3_1_Y_C_sg13g2_a21oi_1_Y
+ VDD VSS overflow_flag_sg13g2_dfrbpq_1_Q_D_sg13g2_inv_1_Y_A_sg13g2_o21ai_1_Y_B1_sg13g2_nand3_1_Y_A_sg13g2_and4_1_A_D_sg13g2_a221oi_1_Y/A2
+ serial_b\[1\]_sg13g2_xor2_1_A/B overflow_flag_sg13g2_dfrbpq_1_Q_D_sg13g2_inv_1_Y_A_sg13g2_o21ai_1_Y_B1_sg13g2_nand3_1_Y_C_sg13g2_a21oi_1_Y_A1_sg13g2_o21ai_1_A2_B1_sg13g2_o21ai_1_A1_Y_sg13g2_nor2_1_B_A_sg13g2_nand3_1_Y_C_sg13g2_a21oi_1_Y/B1
+ overflow_flag_sg13g2_dfrbpq_1_Q_D_sg13g2_inv_1_Y_A_sg13g2_o21ai_1_Y_B1_sg13g2_nand3_1_Y_C_sg13g2_a21oi_1_Y_A1_sg13g2_o21ai_1_A2_B1_sg13g2_o21ai_1_A1_Y_sg13g2_nor2_1_B_A_sg13g2_nand3_1_Y/C
+ sg13g2_a21oi_1
Xuo_out_sg13g2_dfrbpq_1_Q_D_sg13g2_a21oi_1_Y_B1_sg13g2_a21oi_1_Y_A1_sg13g2_nand3_1_Y_C_sg13g2_nand4_1_Y
+ VDD uo_out_sg13g2_dfrbpq_1_Q_D_sg13g2_a21oi_1_Y_B1_sg13g2_a21oi_1_Y_A1_sg13g2_nand3_1_Y/C
+ uio_in[3] uio_in[0] VSS uio_in[4] uo_out_sg13g2_dfrbpq_1_Q_D_sg13g2_a21oi_1_Y_B1_sg13g2_a21oi_1_Y_A1_sg13g2_nand3_1_Y_C_sg13g2_nand4_1_Y/D
+ sg13g2_nand4_1
Xmisr\[3\]_sg13g2_dfrbpq_1_Q VDD misr\[3\]_sg13g2_dfrbpq_1_Q/D misr\[3\]_sg13g2_dfrbpq_1_Q/Q
+ clkbuf_5_7__f_clk/X VSS rst_n sg13g2_dfrbpq_1
Xscan_reg\[15\]_sg13g2_dfrbpq_1_Q_D_sg13g2_a21oi_1_Y VDD VSS scan_out_sg13g2_a22oi_1_A1/B1
+ scan_reg\[16\]_sg13g2_inv_1_A/Y scan_reg\[15\]_sg13g2_o21ai_1_A1_1/Y scan_reg\[15\]_sg13g2_dfrbpq_1_Q/D
+ sg13g2_a21oi_1
Xlfsr\[2\]_sg13g2_dfrbpq_1_Q VDD lfsr\[2\]_sg13g2_dfrbpq_1_Q/D lfsr\[2\]_sg13g2_nand2_1_A/A
+ clkbuf_5_3__f_clk/X VSS rst_n sg13g2_dfrbpq_1
Xbist_a\[7\]_sg13g2_dfrbpq_1_Q_D_sg13g2_o21ai_1_Y_A1_sg13g2_nand2_1_A_Y_sg13g2_a221oi_1_B2_Y_sg13g2_o21ai_1_B1_A2_sg13g2_nand2_1_Y_A_sg13g2_o21ai_1_B1
+ VSS VDD bist_a\[7\]_sg13g2_dfrbpq_1_Q_D_sg13g2_o21ai_1_Y_A1_sg13g2_o21ai_1_A1_Y_sg13g2_nand2b_1_A_N_Y_sg13g2_a221oi_1_C1_B1_sg13g2_mux2_1_X/S
+ bist_a\[7\]_sg13g2_dfrbpq_1_Q_D_sg13g2_o21ai_1_Y_A1_sg13g2_nand2_1_A_Y_sg13g2_a221oi_1_B2_Y_sg13g2_o21ai_1_B1_A2_sg13g2_nand2_1_Y/A
+ bist_a\[3\]_sg13g2_dfrbpq_1_Q_D_sg13g2_o21ai_1_Y/A1 bist_a\[7\]_sg13g2_or2_1_A/A
+ sg13g2_o21ai_1
Xscan_reg\[15\]_sg13g2_dfrbpq_1_Q VDD scan_reg\[15\]_sg13g2_dfrbpq_1_Q/D scan_reg\[15\]_sg13g2_dfrbpq_1_Q/Q
+ clkbuf_5_29__f_clk/X VSS rst_n sg13g2_dfrbpq_1
Xcycle_counter\[5\]_sg13g2_dfrbpq_1_Q_D_sg13g2_and2_1_X cycle_counter\[5\]_sg13g2_dfrbpq_1_Q/D
+ VSS VDD cycle_counter\[5\]_sg13g2_dfrbpq_1_Q_D_sg13g2_and2_1_X/B cycle_counter\[5\]_sg13g2_dfrbpq_1_Q_D_sg13g2_and2_1_X/A
+ sg13g2_and2_1
Xscan_out_sg13g2_a22oi_1_A1_1 uio_out_sg13g2_nand2_1_Y_5/A misr\[1\]_sg13g2_a22oi_1_B2/A2
+ VDD misr\[4\]_sg13g2_a22oi_1_B2/A2 scan_out_sg13g2_dfrbpq_1_Q/Q VSS scan_out_sg13g2_a22oi_1_A1_1/B2
+ sg13g2_a22oi_1
Xscan_reg\[35\]_sg13g2_dfrbpq_1_Q VDD scan_reg\[35\]_sg13g2_dfrbpq_1_Q/D scan_reg\[35\]_sg13g2_inv_1_A/A
+ clkbuf_5_13__f_clk/X VSS rst_n sg13g2_dfrbpq_1
Xscan_reg\[0\]_sg13g2_dfrbpq_1_Q_D_sg13g2_a21oi_1_Y VDD VSS scan_out_sg13g2_a22oi_1_A1/A2
+ scan_reg\[0\]_sg13g2_inv_1_A/Y scan_reg\[1\]_sg13g2_o21ai_1_A1/Y scan_reg\[0\]_sg13g2_dfrbpq_1_Q/D
+ sg13g2_a21oi_1
Xfault_counter\[5\]_sg13g2_dfrbpq_1_Q_D_sg13g2_and2_1_X_A_sg13g2_nand3_1_Y VDD fault_counter\[5\]_sg13g2_dfrbpq_1_Q_D_sg13g2_and2_1_X/A
+ misr\[4\]_sg13g2_a22oi_1_B2/A1 fault_counter\[3\]_sg13g2_dfrbpq_1_Q_D_sg13g2_nor2_1_Y/A
+ fault_counter\[5\]_sg13g2_dfrbpq_1_Q/Q VSS sg13g2_nand3_1
Xmisr\[4\]_sg13g2_inv_1_A_Y_sg13g2_xnor2_1_A_B_sg13g2_o21ai_1_Y_B1_sg13g2_or2_1_X_A_sg13g2_nand3_1_Y_B_sg13g2_a22oi_1_Y
+ misr\[4\]_sg13g2_inv_1_A_Y_sg13g2_xnor2_1_A_B_sg13g2_o21ai_1_Y_B1_sg13g2_or2_1_X_A_sg13g2_nand3_1_Y/B
+ misr\[4\]_sg13g2_inv_1_A_Y_sg13g2_xnor2_1_A_B_sg13g2_o21ai_1_Y_B1_sg13g2_or2_1_X_A_sg13g2_nand3_1_Y_B_sg13g2_a22oi_1_Y/A2
+ VDD misr\[4\]_sg13g2_inv_1_A_Y_sg13g2_xnor2_1_A_B_sg13g2_o21ai_1_Y_B1_sg13g2_or2_1_X_A_sg13g2_nand3_1_Y_B_sg13g2_a22oi_1_Y/B1
+ bist_a\[7\]_sg13g2_dfrbpq_1_Q_D_sg13g2_o21ai_1_Y_A1_sg13g2_nand2_1_A_Y_sg13g2_a221oi_1_A1/C1
+ VSS misr\[4\]_sg13g2_inv_1_A_Y_sg13g2_xnor2_1_A_B_sg13g2_o21ai_1_Y_A1_sg13g2_a21oi_1_Y_A2_sg13g2_a21oi_1_Y/A1
+ sg13g2_a22oi_1
Xscan_reg\[55\]_sg13g2_dfrbpq_1_Q VDD scan_reg\[55\]_sg13g2_dfrbpq_1_Q/D scan_reg\[55\]_sg13g2_nor2_1_A/A
+ clkbuf_5_11__f_clk/X VSS rst_n sg13g2_dfrbpq_1
Xmisr\[4\]_sg13g2_dfrbpq_1_Q_D_sg13g2_a22oi_1_Y_B2_sg13g2_o21ai_1_Y VSS VDD misr\[4\]_sg13g2_dfrbpq_1_Q_D_sg13g2_a22oi_1_Y/B2
+ misr\[4\]_sg13g2_dfrbpq_1_Q_D_sg13g2_a22oi_1_Y_B2_sg13g2_o21ai_1_Y/B1 misr\[4\]_sg13g2_dfrbpq_1_Q_D_sg13g2_a22oi_1_Y_B2_sg13g2_o21ai_1_Y/A2
+ misr\[3\]_sg13g2_dfrbpq_1_Q/Q sg13g2_o21ai_1
Xmisr\[4\]_sg13g2_inv_1_A_Y_sg13g2_xnor2_1_A_B_sg13g2_o21ai_1_Y_A2_sg13g2_o21ai_1_Y
+ VSS VDD misr\[4\]_sg13g2_inv_1_A_Y_sg13g2_xnor2_1_A_B_sg13g2_o21ai_1_Y/A2 misr\[4\]_sg13g2_inv_1_A_Y_sg13g2_xnor2_1_A_B_sg13g2_o21ai_1_Y_B1_sg13g2_or2_1_X/B
+ misr\[4\]_sg13g2_inv_1_A_Y_sg13g2_xnor2_1_A_B_sg13g2_o21ai_1_Y_B1_sg13g2_or2_1_X/A
+ misr\[4\]_sg13g2_inv_1_A_Y_sg13g2_xnor2_1_A_B_sg13g2_o21ai_1_Y_A2_sg13g2_o21ai_1_Y/A1
+ sg13g2_o21ai_1
Xoverflow_flag_sg13g2_dfrbpq_1_Q_D_sg13g2_inv_1_Y_A_sg13g2_o21ai_1_Y_B1_sg13g2_nand3_1_Y_A_sg13g2_and4_1_A_D_sg13g2_a221oi_1_Y_B1_sg13g2_nand3_1_Y_C_sg13g2_nand2_1_Y
+ overflow_flag_sg13g2_dfrbpq_1_Q_D_sg13g2_inv_1_Y_A_sg13g2_o21ai_1_Y_B1_sg13g2_nand3_1_Y_A_sg13g2_and4_1_A_D_sg13g2_a221oi_1_Y_B1_sg13g2_nand3_1_Y/C
+ VDD carry_flag_sg13g2_o21ai_1_A1_B1_sg13g2_nand2_1_Y_B_sg13g2_a21oi_1_Y_A2_sg13g2_a21oi_1_Y/A1
+ VSS uo_out_sg13g2_dfrbpq_1_Q_6_D_sg13g2_a21oi_1_Y_A2_sg13g2_a21o_1_X_A2_sg13g2_and2_1_X_A_sg13g2_a221oi_1_Y_C1_sg13g2_nand3_1_Y_C_sg13g2_a221oi_1_Y/A2
+ sg13g2_nand2_1
Xlfsr\[6\]_sg13g2_a22oi_1_A1 lfsr\[6\]_sg13g2_a22oi_1_A1/Y lfsr\[7\]_sg13g2_a22oi_1_A1/A2
+ VDD lfsr\[7\]_sg13g2_a22oi_1_A1/B1 lfsr\[6\]_sg13g2_mux2_1_A1/A1 VSS lfsr\[5\]_sg13g2_dfrbpq_1_Q/Q
+ sg13g2_a22oi_1
Xscan_reg\[3\]_sg13g2_nor2_1_A_B_sg13g2_nand2b_1_Y VSS ui_in[3] scan_reg\[3\]_sg13g2_nor2_1_A/B
+ ui_in[6] VDD sg13g2_nand2b_1
Xscan_reg\[17\]_sg13g2_o21ai_1_A1_1 VSS VDD scan_reg\[17\]_sg13g2_o21ai_1_A1_1/Y operation\[1\]_sg13g2_nand2b_1_A_N/Y
+ scan_reg\[41\]_sg13g2_nor2_1_A/B scan_reg\[17\]_sg13g2_dfrbpq_1_Q/Q sg13g2_o21ai_1
Xcarry_flag_sg13g2_o21ai_1_A1_B1_sg13g2_nand2_1_Y_B_sg13g2_a21oi_1_Y_A2_sg13g2_a21oi_1_Y_B1_sg13g2_o21ai_1_B1_Y_sg13g2_a221oi_1_B1_1_B2_sg13g2_xnor2_1_Y_B_sg13g2_o21ai_1_Y_A1_sg13g2_nand2b_1_A_N_Y_sg13g2_nand4_1_C_B_sg13g2_a22oi_1_Y_B2_sg13g2_and2_1_X
+ carry_flag_sg13g2_o21ai_1_A1_B1_sg13g2_nand2_1_Y_B_sg13g2_a21oi_1_Y_A2_sg13g2_a21oi_1_Y_B1_sg13g2_o21ai_1_B1_Y_sg13g2_a221oi_1_B1_1_B2_sg13g2_xnor2_1_Y_B_sg13g2_o21ai_1_Y_A1_sg13g2_nand2b_1_A_N_Y_sg13g2_nand4_1_C_B_sg13g2_a22oi_1_Y/B2
+ VSS VDD serial_b\[1\]_sg13g2_xor2_1_A/B serial_b\[1\]_sg13g2_xor2_1_A/A sg13g2_and2_1
Xclkbuf_5_25__f_clk clkload4/A VSS clkbuf_4_12_0_clk/X VDD sg13g2_buf_4
Xbist_a\[7\]_sg13g2_dfrbpq_1_Q_D_sg13g2_o21ai_1_Y_A1_sg13g2_nand2_1_A_Y_sg13g2_a221oi_1_B2_C1_sg13g2_or2_1_X_A_sg13g2_nand2b_1_A_N
+ VSS bist_a\[7\]_sg13g2_dfrbpq_1_Q_D_sg13g2_o21ai_1_Y_A1_sg13g2_nand2_1_A_Y_sg13g2_a221oi_1_B2_C1_sg13g2_or2_1_X/A
+ bist_a\[7\]_sg13g2_dfrbpq_1_Q_D_sg13g2_o21ai_1_Y_A1_sg13g2_nand2_1_A_Y_sg13g2_a221oi_1_A1/B1
+ bist_a\[7\]_sg13g2_dfrbpq_1_Q_D_sg13g2_o21ai_1_Y_A1_sg13g2_o21ai_1_A1/A2 VDD sg13g2_nand2b_1
Xscan_reg\[39\]_sg13g2_a22oi_1_B2 scan_reg\[39\]_sg13g2_a22oi_1_B2/Y misr\[6\]_sg13g2_dfrbpq_1_Q/Q
+ VDD scan_out_sg13g2_a22oi_1_A1/B1 ui_in[3] VSS scan_reg\[39\]_sg13g2_inv_1_A/A sg13g2_a22oi_1
Xscan_reg\[7\]_sg13g2_dfrbpq_1_Q VDD scan_reg\[7\]_sg13g2_dfrbpq_1_Q/D scan_reg\[7\]_sg13g2_inv_1_A/A
+ clkbuf_5_23__f_clk/X VSS rst_n sg13g2_dfrbpq_1
Xbist_pattern_count\[3\]_sg13g2_nand4_1_D VDD bist_pattern_count\[3\]_sg13g2_nand4_1_D/Y
+ bist_pattern_count\[1\]_sg13g2_and3_1_A/B bist_pattern_count\[3\]_sg13g2_nand4_1_D/C
+ VSS bist_pattern_count\[1\]_sg13g2_and3_1_A/A bist_pattern_count\[3\]_sg13g2_nor2_1_A/A
+ sg13g2_nand4_1
Xuo_out_sg13g2_dfrbpq_1_Q_6_D_sg13g2_a21oi_1_Y_A2_sg13g2_a21o_1_X_A2_sg13g2_and2_1_X_A_sg13g2_a221oi_1_Y_B2_sg13g2_and2_1_X_B_sg13g2_o21ai_1_Y_B1_sg13g2_xor2_1_X
+ uo_out_sg13g2_dfrbpq_1_Q_6_D_sg13g2_a21oi_1_Y_A2_sg13g2_a21o_1_X_A2_sg13g2_and2_1_X_A_sg13g2_a221oi_1_Y_B2_sg13g2_and2_1_X_B_sg13g2_o21ai_1_Y/B1
+ VDD serial_b\[4\]_sg13g2_nand2_1_A/B serial_b\[4\]_sg13g2_nand2_1_A/A VSS sg13g2_xor2_1
Xscan_reg\[42\]_sg13g2_dfrbpq_1_Q_D_sg13g2_a221oi_1_Y scan_reg\[43\]_sg13g2_nor2_1_A/Y
+ scan_reg\[42\]_sg13g2_dfrbpq_1_Q/D scan_out_sg13g2_a22oi_1_A1/A2 scan_reg\[42\]_sg13g2_inv_1_A/Y
+ ui_in[3] VDD scan_reg\[42\]_sg13g2_dfrbpq_1_Q_D_sg13g2_a221oi_1_Y/A1 VSS sg13g2_a221oi_1
Xmisr\[2\]_sg13g2_dfrbpq_1_Q_D_sg13g2_o21ai_1_Y VSS VDD misr\[2\]_sg13g2_dfrbpq_1_Q/D
+ misr\[2\]_sg13g2_dfrbpq_1_Q_D_sg13g2_o21ai_1_Y/B1 misr\[1\]_sg13g2_inv_1_A_Y_sg13g2_xnor2_1_A/Y
+ misr\[6\]_sg13g2_dfrbpq_1_Q_D_sg13g2_o21ai_1_Y/A1 sg13g2_o21ai_1
Xcarry_flag_sg13g2_o21ai_1_A1_B1_sg13g2_nand2_1_Y_B_sg13g2_a21oi_1_Y_A2_sg13g2_a21oi_1_Y_B1_sg13g2_o21ai_1_B1_Y_sg13g2_a221oi_1_B1_1_B2_sg13g2_xnor2_1_Y_B_sg13g2_o21ai_1_Y_A1_sg13g2_nand2b_1_A_N
+ VSS carry_flag_sg13g2_o21ai_1_A1_B1_sg13g2_nand2_1_Y_B_sg13g2_a21oi_1_Y_A2_sg13g2_a21oi_1_Y_B1_sg13g2_o21ai_1_B1_Y_sg13g2_a221oi_1_B1_1_B2_sg13g2_xnor2_1_Y_B_sg13g2_o21ai_1_Y/A1
+ carry_flag_sg13g2_o21ai_1_A1_B1_sg13g2_nand2_1_Y_B_sg13g2_a21oi_1_Y_A2_sg13g2_a21oi_1_Y_B1_sg13g2_o21ai_1_B1_Y_sg13g2_a221oi_1_B1_1_B2_sg13g2_xnor2_1_Y_B_sg13g2_o21ai_1_Y_A1_sg13g2_nand2b_1_A_N/Y
+ serial_opcode\[2\]_sg13g2_nor3_1_A/Y VDD sg13g2_nand2b_1
Xuo_out_sg13g2_dfrbpq_1_Q_D_sg13g2_a21oi_1_Y_B1_sg13g2_a21oi_1_Y_A2_sg13g2_nand3b_1_Y_B_sg13g2_nand3_1_Y
+ VDD uo_out_sg13g2_dfrbpq_1_Q_D_sg13g2_a21oi_1_Y_B1_sg13g2_a21oi_1_Y_A2_sg13g2_nand3b_1_Y/B
+ uo_out_sg13g2_dfrbpq_1_Q_D_sg13g2_a21oi_1_Y_B1_sg13g2_a21oi_1_Y_A1_sg13g2_nand3_1_Y/A
+ uo_out_sg13g2_dfrbpq_1_Q_D_sg13g2_a21oi_1_Y_B1_sg13g2_a21oi_1_Y_A1_sg13g2_nand3_1_Y/B
+ uo_out_sg13g2_dfrbpq_1_Q_5_D_sg13g2_a21oi_1_Y_A2_sg13g2_o21ai_1_Y_A2_sg13g2_mux2_1_X/A0
+ VSS sg13g2_nand3_1
Xlfsr\[4\]_sg13g2_dfrbpq_1_Q_D_sg13g2_inv_1_Y_A_sg13g2_a22oi_1_Y lfsr\[4\]_sg13g2_dfrbpq_1_Q_D_sg13g2_inv_1_Y/A
+ lfsr\[7\]_sg13g2_a22oi_1_A1/A2 VDD lfsr\[7\]_sg13g2_a22oi_1_A1/B1 lfsr\[4\]_sg13g2_dfrbpq_1_Q/Q
+ VSS lfsr\[7\]_sg13g2_xnor2_1_B/A sg13g2_a22oi_1
Xuo_out_sg13g2_dfrbpq_1_Q_1_D_sg13g2_a21oi_1_Y VDD VSS uo_out_sg13g2_dfrbpq_1_Q_1_D_sg13g2_a21oi_1_Y/A2
+ ui_in[2] uo_out_sg13g2_dfrbpq_1_Q_1_D_sg13g2_a21oi_1_Y/B1 uo_out_sg13g2_dfrbpq_1_Q_1/D
+ sg13g2_a21oi_1
Xuio_out_sg13g2_nand2_1_Y_4_B_sg13g2_a22oi_1_Y uio_out_sg13g2_nand2_1_Y_4/B misr\[4\]_sg13g2_a22oi_1_B2/A2
+ VDD misr\[4\]_sg13g2_a22oi_1_B2/B1 fault_counter\[0\]_sg13g2_dfrbpq_1_Q/Q VSS misr\[0\]_sg13g2_dfrbpq_1_Q/Q
+ sg13g2_a22oi_1
Xclkbuf_5_6__f_clk clkbuf_5_6__f_clk/X VSS clkbuf_4_3_0_clk/X VDD sg13g2_buf_4
Xbist_done_sg13g2_dfrbpq_1_Q_D_sg13g2_o21ai_1_Y_B1_sg13g2_o21ai_1_Y_A2_sg13g2_dfrbpq_1_Q
+ VDD bist_state\[3\]_sg13g2_inv_1_A_Y_sg13g2_a21o_1_A1/X bist_state\[1\]_sg13g2_a21oi_1_A1/A2
+ clkbuf_5_8__f_clk/X VSS rst_n sg13g2_dfrbpq_1
Xoverflow_flag_sg13g2_dfrbpq_1_Q_D_sg13g2_inv_1_Y_A_sg13g2_o21ai_1_Y_B1_sg13g2_nand3_1_Y_A_sg13g2_nand2_1_Y_B_sg13g2_a21oi_1_Y
+ VDD VSS overflow_flag_sg13g2_dfrbpq_1_Q_D_sg13g2_inv_1_Y_A_sg13g2_o21ai_1_Y_B1_sg13g2_nand3_1_Y_A_sg13g2_nand2_1_Y_B_sg13g2_a21oi_1_Y/A2
+ serial_b\[6\]_sg13g2_nand2_1_A/Y overflow_flag_sg13g2_dfrbpq_1_Q_D_sg13g2_inv_1_Y_A_sg13g2_o21ai_1_Y_B1_sg13g2_nand3_1_Y_A_sg13g2_nand2_1_Y_B_sg13g2_a21oi_1_Y/B1
+ overflow_flag_sg13g2_dfrbpq_1_Q_D_sg13g2_inv_1_Y_A_sg13g2_o21ai_1_Y_B1_sg13g2_nand3_1_Y_A_sg13g2_nand2_1_Y/B
+ sg13g2_a21oi_1
Xuo_out_sg13g2_dfrbpq_1_Q_D_sg13g2_a21oi_1_Y_B1_sg13g2_a21oi_1_Y_A1_sg13g2_nand3_1_Y_B_sg13g2_a221oi_1_Y_C1_sg13g2_o21ai_1_Y_A2_sg13g2_xnor2_1_Y_B_sg13g2_a21oi_1_Y
+ VDD VSS carry_flag_sg13g2_o21ai_1_A1_B1_sg13g2_nand2_1_Y_B_sg13g2_a21oi_1_Y_A2_sg13g2_a21oi_1_Y_B1_sg13g2_o21ai_1_B1_Y_sg13g2_a221oi_1_B1_1_B2_sg13g2_xnor2_1_Y/B
+ serial_b\[2\]_sg13g2_xor2_1_A/X uo_out_sg13g2_dfrbpq_1_Q_6_D_sg13g2_a21oi_1_Y_A2_sg13g2_a21o_1_X_A2_sg13g2_and2_1_X_B_sg13g2_a22oi_1_Y_B2_sg13g2_and2_1_X_B_sg13g2_o21ai_1_Y_A2_sg13g2_a221oi_1_Y/C1
+ uo_out_sg13g2_dfrbpq_1_Q_D_sg13g2_a21oi_1_Y_B1_sg13g2_a21oi_1_Y_A1_sg13g2_nand3_1_Y_B_sg13g2_a221oi_1_Y_C1_sg13g2_o21ai_1_Y_A2_sg13g2_xnor2_1_Y/B
+ sg13g2_a21oi_1
Xlfsr\[7\]_sg13g2_xnor2_1_B_Y_sg13g2_xnor2_1_A_B_sg13g2_xnor2_1_Y lfsr\[7\]_sg13g2_xnor2_1_B_Y_sg13g2_xnor2_1_A/B
+ lfsr\[4\]_sg13g2_dfrbpq_1_Q/Q VDD lfsr\[5\]_sg13g2_dfrbpq_1_Q/Q VSS sg13g2_xnor2_1
Xserial_a\[0\]_sg13g2_dfrbpq_1_Q_D_sg13g2_o21ai_1_Y_B1_sg13g2_nand2_1_Y serial_a\[0\]_sg13g2_dfrbpq_1_Q_D_sg13g2_o21ai_1_Y/B1
+ VDD serial_b\[1\]_sg13g2_xor2_1_A/B VSS ui_in[1] sg13g2_nand2_1
Xcycle_counter\[1\]_sg13g2_dfrbpq_1_Q VDD cycle_counter\[1\]_sg13g2_dfrbpq_1_Q/D cycle_counter\[1\]_sg13g2_dfrbpq_1_Q/Q
+ clkload4/A VSS rst_n sg13g2_dfrbpq_1
Xmisr\[7\]_sg13g2_dfrbpq_1_Q_D_sg13g2_a22oi_1_Y_B2_sg13g2_o21ai_1_Y_A2_sg13g2_a22oi_1_Y_A1_sg13g2_a21oi_1_Y_A1_sg13g2_o21ai_1_Y_A2_sg13g2_a21oi_1_Y
+ VDD VSS lfsr\[6\]_sg13g2_mux2_1_A1/A0 bist_a\[2\]_sg13g2_dfrbpq_1_Q/Q misr\[1\]_sg13g2_inv_1_A_Y_sg13g2_xnor2_1_A_B_sg13g2_o21ai_1_Y_A2_sg13g2_nand3_1_Y_B_sg13g2_nor3_1_Y_B_sg13g2_a21oi_1_B1_A2_sg13g2_nor2b_1_Y/A
+ misr\[7\]_sg13g2_dfrbpq_1_Q_D_sg13g2_a22oi_1_Y_B2_sg13g2_o21ai_1_Y_A2_sg13g2_a22oi_1_Y_A1_sg13g2_a21oi_1_Y_A1_sg13g2_o21ai_1_Y/A2
+ sg13g2_a21oi_1
Xserial_b\[3\]_sg13g2_dfrbpq_1_Q_D_sg13g2_o21ai_1_Y_B1_sg13g2_nand2_1_Y serial_b\[3\]_sg13g2_dfrbpq_1_Q_D_sg13g2_o21ai_1_Y/B1
+ VDD serial_b\[4\]_sg13g2_nand2_1_A/A VSS ui_in[1] sg13g2_nand2_1
Xoverflow_flag_sg13g2_dfrbpq_1_Q_D_sg13g2_inv_1_Y_A_sg13g2_o21ai_1_Y_B1_sg13g2_nand3_1_Y_A_sg13g2_and4_1_A_B_sg13g2_or2_1_X
+ serial_a\[7\]_sg13g2_dfrbpq_1_Q/Q VSS overflow_flag_sg13g2_dfrbpq_1_Q_D_sg13g2_inv_1_Y_A_sg13g2_o21ai_1_Y_B1_sg13g2_nand3_1_Y_A_sg13g2_and4_1_A_B_sg13g2_or2_1_X/B
+ overflow_flag_sg13g2_dfrbpq_1_Q_D_sg13g2_inv_1_Y_A_sg13g2_o21ai_1_Y_B1_sg13g2_nand3_1_Y_A_sg13g2_and4_1_A/B
+ VDD sg13g2_or2_1
Xbist_a\[0\]_sg13g2_dfrbpq_1_Q_D_sg13g2_a21oi_1_Y VDD VSS lfsr\[7\]_sg13g2_nand2_1_A/B
+ lfsr\[1\]_sg13g2_a22oi_1_A1_B2_sg13g2_inv_1_Y/A bist_a\[0\]_sg13g2_dfrbpq_1_Q_D_sg13g2_a21oi_1_Y/B1
+ bist_a\[0\]_sg13g2_dfrbpq_1_Q/D sg13g2_a21oi_1
Xmisr\[1\]_sg13g2_inv_1_A_Y_sg13g2_xnor2_1_A_B_sg13g2_o21ai_1_Y_A2_sg13g2_nand3_1_Y_B_sg13g2_nor3_1_Y_B_sg13g2_a21oi_1_Y
+ VDD VSS bist_a\[7\]_sg13g2_dfrbpq_1_Q_D_sg13g2_o21ai_1_Y_A1_sg13g2_nand2_1_A_Y_sg13g2_a221oi_1_A1_A2_sg13g2_nand3_1_Y/C
+ lfsr\[6\]_sg13g2_mux2_1_A1/A0 misr\[1\]_sg13g2_inv_1_A_Y_sg13g2_xnor2_1_A_B_sg13g2_o21ai_1_Y_A2_sg13g2_nand3_1_Y_B_sg13g2_nor3_1_Y_B_sg13g2_a21oi_1_Y/B1
+ misr\[1\]_sg13g2_inv_1_A_Y_sg13g2_xnor2_1_A_B_sg13g2_o21ai_1_Y_A2_sg13g2_nand3_1_Y_B_sg13g2_nor3_1_Y/B
+ sg13g2_a21oi_1
Xscan_reg\[28\]_sg13g2_dfrbpq_1_Q VDD scan_reg\[28\]_sg13g2_dfrbpq_1_Q/D scan_reg\[28\]_sg13g2_nand2b_1_B/B
+ clkbuf_5_30__f_clk/X VSS rst_n sg13g2_dfrbpq_1
Xcarry_flag_sg13g2_o21ai_1_A1_B1_sg13g2_nand2_1_Y_A_sg13g2_nand3_1_Y_B_sg13g2_nand3_1_C_Y_sg13g2_o21ai_1_B1
+ VSS VDD uo_out_sg13g2_dfrbpq_1_Q_6_D_sg13g2_a21oi_1_Y_A2_sg13g2_a21o_1_X_A2_sg13g2_and2_1_X_B_sg13g2_a22oi_1_Y/A2
+ carry_flag_sg13g2_o21ai_1_A1_B1_sg13g2_nand2_1_Y_A_sg13g2_nand3_1_Y_B_sg13g2_nand3_1_C/Y
+ carry_flag_sg13g2_o21ai_1_A1_B1_sg13g2_nand2_1_Y_A_sg13g2_nand3_1_Y_B_sg13g2_nand3_1_C_Y_sg13g2_o21ai_1_B1/A2
+ carry_flag_sg13g2_o21ai_1_A1_B1_sg13g2_nand2_1_Y_A_sg13g2_nand3_1_Y_B_sg13g2_nand3_1_C_Y_sg13g2_o21ai_1_B1/A1
+ sg13g2_o21ai_1
Xoperand_b\[3\]_sg13g2_nand2b_1_A_N VSS operand_b\[3\]_sg13g2_nor2_1_A/A operand_b\[3\]_sg13g2_nand2b_1_A_N/Y
+ ui_in[3] VDD sg13g2_nand2b_1
Xscan_reg\[35\]_sg13g2_dfrbpq_1_Q_D_sg13g2_o21ai_1_Y VSS VDD scan_reg\[35\]_sg13g2_dfrbpq_1_Q/D
+ scan_reg\[36\]_sg13g2_a22oi_1_B1/Y scan_reg\[41\]_sg13g2_nor2_1_A/B scan_reg\[35\]_sg13g2_inv_1_A/Y
+ sg13g2_o21ai_1
Xscan_reg\[48\]_sg13g2_dfrbpq_1_Q VDD scan_reg\[48\]_sg13g2_dfrbpq_1_Q/D scan_reg\[48\]_sg13g2_inv_1_A/A
+ clkbuf_5_10__f_clk/X VSS rst_n sg13g2_dfrbpq_1
Xserial_b\[1\]_sg13g2_xor2_1_A serial_b\[1\]_sg13g2_xor2_1_A/X VDD serial_b\[1\]_sg13g2_xor2_1_A/B
+ serial_b\[1\]_sg13g2_xor2_1_A/A VSS sg13g2_xor2_1
Xclkbuf_5_31__f_clk clkbuf_5_31__f_clk/X VSS clkbuf_4_15_0_clk/X VDD sg13g2_buf_4
Xuo_out_sg13g2_dfrbpq_1_Q_D_sg13g2_a21oi_1_Y_B1_sg13g2_a21oi_1_Y_A1_sg13g2_nand3_1_Y_B_sg13g2_a221oi_1_Y_C1_sg13g2_o21ai_1_Y_A1_sg13g2_nor2_1_B_Y_sg13g2_a22oi_1_B2_B1_sg13g2_nand3_1_Y
+ VDD uo_out_sg13g2_dfrbpq_1_Q_D_sg13g2_a21oi_1_Y_B1_sg13g2_a21oi_1_Y_A1_sg13g2_nand3_1_Y_B_sg13g2_a221oi_1_Y_C1_sg13g2_o21ai_1_Y_A1_sg13g2_nor2_1_B_Y_sg13g2_a22oi_1_B2/B1
+ uo_out_sg13g2_dfrbpq_1_Q_5_D_sg13g2_a21oi_1_Y_A2_sg13g2_o21ai_1_Y_B1_sg13g2_or2_1_X_B_sg13g2_nand2_1_Y_A_sg13g2_a221oi_1_Y_C1_sg13g2_nand4_1_Y_B_sg13g2_o21ai_1_Y_B1_sg13g2_a21o_1_X/A1
+ uo_out_sg13g2_dfrbpq_1_Q_D_sg13g2_a21oi_1_Y_B1_sg13g2_a21oi_1_Y_A1_sg13g2_nand3_1_Y_B_sg13g2_a221oi_1_Y_C1_sg13g2_o21ai_1_Y_A1_sg13g2_nor2_1_B_Y_sg13g2_a22oi_1_B2_B1_sg13g2_nand3_1_Y/C
+ carry_flag_sg13g2_o21ai_1_A1_B1_sg13g2_nand2_1_Y_A_sg13g2_nand3_1_Y_B_sg13g2_nand3_1_C_Y_sg13g2_o21ai_1_B1_A2_sg13g2_nor3_1_Y_C_sg13g2_nor4_1_Y_D_sg13g2_nand2_1_Y/A
+ VSS sg13g2_nand3_1
Xscan_reg\[16\]_sg13g2_dfrbpq_1_Q_D_sg13g2_a21oi_1_Y VDD VSS scan_out_sg13g2_a22oi_1_A1/A2
+ scan_reg\[16\]_sg13g2_inv_1_A/Y scan_reg\[17\]_sg13g2_o21ai_1_A1/Y scan_reg\[16\]_sg13g2_dfrbpq_1_Q/D
+ sg13g2_a21oi_1
Xuo_out_sg13g2_dfrbpq_1_Q_D_sg13g2_a21oi_1_Y_B1_sg13g2_a21oi_1_Y_A1_sg13g2_nand3_1_Y_B_sg13g2_a221oi_1_Y_B1_sg13g2_xnor2_1_Y_A_sg13g2_a21oi_1_Y_A2_sg13g2_o21ai_1_Y
+ VSS VDD uo_out_sg13g2_dfrbpq_1_Q_D_sg13g2_a21oi_1_Y_B1_sg13g2_a21oi_1_Y_A1_sg13g2_nand3_1_Y_B_sg13g2_a221oi_1_Y_B1_sg13g2_xnor2_1_Y_A_sg13g2_a21oi_1_Y/A2
+ uo_out_sg13g2_dfrbpq_1_Q_D_sg13g2_a21oi_1_Y_B1_sg13g2_a21oi_1_Y_A1_sg13g2_nand3_1_Y_B_sg13g2_a221oi_1_Y_B1_sg13g2_xnor2_1_Y_A_sg13g2_a21oi_1_Y_A2_sg13g2_o21ai_1_Y/B1
+ uo_out_sg13g2_dfrbpq_1_Q_D_sg13g2_a21oi_1_Y_B1_sg13g2_a21oi_1_Y_A1_sg13g2_nand3_1_Y_B_sg13g2_a221oi_1_Y_B1_sg13g2_xnor2_1_Y_A_sg13g2_a21oi_1_Y_A2_sg13g2_o21ai_1_Y/A2
+ serial_b\[1\]_sg13g2_xor2_1_A/X sg13g2_o21ai_1
Xmisr\[4\]_sg13g2_dfrbpq_1_Q_D_sg13g2_a22oi_1_Y_B2_sg13g2_o21ai_1_Y_A2_sg13g2_a21oi_1_Y_B1_sg13g2_nor3_1_Y_A_sg13g2_and2_1_X
+ misr\[4\]_sg13g2_dfrbpq_1_Q_D_sg13g2_a22oi_1_Y_B2_sg13g2_o21ai_1_Y_A2_sg13g2_a21oi_1_Y_B1_sg13g2_nor3_1_Y/A
+ VSS VDD misr\[4\]_sg13g2_inv_1_A_Y_sg13g2_xnor2_1_A_B_sg13g2_o21ai_1_Y_A1_sg13g2_a21oi_1_Y/A2
+ uo_out_sg13g2_dfrbpq_1_Q_5_D_sg13g2_a21oi_1_Y_A2_sg13g2_o21ai_1_Y_A2_sg13g2_mux2_1_X/A0
+ sg13g2_and2_1
Xbist_done_sg13g2_inv_1_A bist_done_sg13g2_inv_1_A/Y bist_done_sg13g2_inv_1_A/A VSS
+ VDD sg13g2_inv_1
Xmisr\[4\]_sg13g2_inv_1_A_Y_sg13g2_xnor2_1_A_B_sg13g2_o21ai_1_Y_B1_sg13g2_or2_1_X_A_sg13g2_nand3_1_Y_C_sg13g2_a21oi_1_Y_B1_sg13g2_a221oi_1_Y_B1_sg13g2_nor2_1_Y
+ misr\[1\]_sg13g2_inv_1_A_Y_sg13g2_xnor2_1_A_B_sg13g2_o21ai_1_Y_A2_sg13g2_nand3_1_Y_C_sg13g2_a22oi_1_Y_A2_sg13g2_xnor2_1_Y_B_sg13g2_a21oi_1_Y/A1
+ VDD misr\[4\]_sg13g2_inv_1_A_Y_sg13g2_xnor2_1_A_B_sg13g2_o21ai_1_Y_B1_sg13g2_or2_1_X_A_sg13g2_nand3_1_Y_C_sg13g2_a21oi_1_Y_B1_sg13g2_a221oi_1_Y/B1
+ VSS misr\[1\]_sg13g2_inv_1_A_Y_sg13g2_xnor2_1_A_B_sg13g2_o21ai_1_Y_A2_sg13g2_nand3_1_Y_C_sg13g2_a22oi_1_Y_A2_sg13g2_xnor2_1_Y_B_sg13g2_a21oi_1_Y/A2
+ sg13g2_nor2_1
Xserial_b\[6\]_sg13g2_nand2b_1_A_N VSS serial_b\[6\]_sg13g2_and2_1_A/A serial_b\[6\]_sg13g2_nand2b_1_A_N/Y
+ serial_b\[6\]_sg13g2_and2_1_A/B VDD sg13g2_nand2b_1
Xuio_out_sg13g2_nand2_1_Y_1_A_sg13g2_a22oi_1_Y uio_out_sg13g2_nand2_1_Y_1/A bist_done_sg13g2_a22oi_1_B2/A2
+ VDD misr\[4\]_sg13g2_a22oi_1_B2/B1 cycle_counter\[3\]_sg13g2_dfrbpq_1_Q/Q VSS misr\[3\]_sg13g2_dfrbpq_1_Q/Q
+ sg13g2_a22oi_1
Xbist_pattern_count\[7\]_sg13g2_dfrbpq_1_Q VDD bist_pattern_count\[7\]_sg13g2_dfrbpq_1_Q/D
+ bist_pattern_count\[7\]_sg13g2_dfrbpq_1_Q/Q clkbuf_5_6__f_clk/X VSS rst_n sg13g2_dfrbpq_1
Xcarry_flag_sg13g2_o21ai_1_A1_B1_sg13g2_nand2_1_Y_B_sg13g2_a21oi_1_Y_A2_sg13g2_a21oi_1_Y_B1_sg13g2_o21ai_1_B1_Y_sg13g2_a221oi_1_B1_1
+ overflow_flag_sg13g2_dfrbpq_1_Q_D_sg13g2_inv_1_Y_A_sg13g2_o21ai_1_Y_B1_sg13g2_nand3_1_Y_C_sg13g2_a21oi_1_Y_A1_sg13g2_o21ai_1_A2/A1
+ carry_flag_sg13g2_o21ai_1_A1_B1_sg13g2_nand2_1_Y_B_sg13g2_a21oi_1_Y_A2_sg13g2_a21oi_1_Y_B1_sg13g2_o21ai_1_B1_Y_sg13g2_a221oi_1_B1_1/Y
+ carry_flag_sg13g2_o21ai_1_A1_B1_sg13g2_nand2_1_Y_B_sg13g2_a21oi_1_Y_A2_sg13g2_a21oi_1_Y_B1_sg13g2_o21ai_1_B1_Y_sg13g2_a221oi_1_B1_1/B2
+ carry_flag_sg13g2_o21ai_1_A1_B1_sg13g2_nand2_1_Y_B_sg13g2_a21oi_1_Y_A2_sg13g2_a21oi_1_Y_B1_sg13g2_o21ai_1_B1/Y
+ carry_flag_sg13g2_o21ai_1_A1_B1_sg13g2_nand2_1_Y_B_sg13g2_a21oi_1_Y_A2_sg13g2_a21oi_1_Y/A2
+ VDD overflow_flag_sg13g2_dfrbpq_1_Q_D_sg13g2_inv_1_Y_A_sg13g2_o21ai_1_Y_B1_sg13g2_nand3_1_Y_A_sg13g2_and4_1_A_C_sg13g2_o21ai_1_Y/B1
+ VSS sg13g2_a221oi_1
Xoperand_b\[2\]_sg13g2_dfrbpq_1_Q VDD operand_b\[2\]_sg13g2_dfrbpq_1_Q/D operand_b\[2\]_sg13g2_nor2_1_A/A
+ clkbuf_5_16__f_clk/X VSS rst_n sg13g2_dfrbpq_1
Xuio_out_sg13g2_nand2_1_Y_1 uio_out[3] VDD uio_out_sg13g2_nand2_1_Y_1/A VSS uio_out_sg13g2_nand2_1_Y_1/B
+ sg13g2_nand2_1
Xscan_reg\[1\]_sg13g2_dfrbpq_1_Q_D_sg13g2_a21oi_1_Y VDD VSS scan_out_sg13g2_a22oi_1_A1/B1
+ scan_reg\[2\]_sg13g2_inv_1_A/Y scan_reg\[1\]_sg13g2_o21ai_1_A1_1/Y scan_reg\[1\]_sg13g2_dfrbpq_1_Q/D
+ sg13g2_a21oi_1
Xmisr\[1\]_sg13g2_inv_1_A_Y_sg13g2_xnor2_1_A_B_sg13g2_o21ai_1_Y_A2_sg13g2_nand3_1_Y_C_sg13g2_a22oi_1_Y
+ misr\[1\]_sg13g2_inv_1_A_Y_sg13g2_xnor2_1_A_B_sg13g2_o21ai_1_Y_A2_sg13g2_nand3_1_Y/C
+ misr\[1\]_sg13g2_inv_1_A_Y_sg13g2_xnor2_1_A_B_sg13g2_o21ai_1_Y_A2_sg13g2_nand3_1_Y_C_sg13g2_a22oi_1_Y/A2
+ VDD misr\[1\]_sg13g2_inv_1_A_Y_sg13g2_xnor2_1_A_B_sg13g2_o21ai_1_Y_A2_sg13g2_nand3_1_Y_C_sg13g2_a22oi_1_Y/B1
+ misr\[1\]_sg13g2_inv_1_A_Y_sg13g2_xnor2_1_A_B_sg13g2_o21ai_1_Y_A2_sg13g2_nand3_1_Y_C_sg13g2_a22oi_1_Y/A1
+ VSS bist_a\[7\]_sg13g2_dfrbpq_1_Q_D_sg13g2_o21ai_1_Y_A1_sg13g2_nand2_1_A_Y_sg13g2_a221oi_1_B2/A1
+ sg13g2_a22oi_1
Xuio_out_sg13g2_nand2_1_Y uio_out[7] VDD uio_out_sg13g2_nand2_1_Y/A VSS uio_out_sg13g2_nand2_1_Y/B
+ sg13g2_nand2_1
Xuio_out_sg13g2_nand2_1_Y_B_sg13g2_a22oi_1_Y uio_out_sg13g2_nand2_1_Y/B misr\[4\]_sg13g2_a22oi_1_B2/A2
+ VDD misr\[4\]_sg13g2_a22oi_1_B2/B1 fault_counter\[7\]_sg13g2_dfrbpq_1_Q/Q VSS misr\[7\]_sg13g2_dfrbpq_1_Q/Q
+ sg13g2_a22oi_1
Xbist_state\[3\]_sg13g2_inv_1_A bist_state\[3\]_sg13g2_inv_1_A/Y bist_fault_sg13g2_o21ai_1_A2/B1
+ VSS VDD sg13g2_inv_1
Xmisr\[1\]_sg13g2_inv_1_A_Y_sg13g2_xnor2_1_A_B_sg13g2_o21ai_1_Y_A2_sg13g2_nand3_1_Y_B_sg13g2_nor3_1_Y_A_sg13g2_nor2_1_Y
+ bist_a\[0\]_sg13g2_dfrbpq_1_Q/Q VDD misr\[1\]_sg13g2_inv_1_A_Y_sg13g2_xnor2_1_A_B_sg13g2_o21ai_1_Y_A2_sg13g2_nand3_1_Y_B_sg13g2_nor3_1_Y/A
+ VSS misr\[1\]_sg13g2_inv_1_A_Y_sg13g2_xnor2_1_A_B_sg13g2_o21ai_1_Y_A2_sg13g2_nand3_1_Y_B_sg13g2_nor3_1_Y_A_sg13g2_nor2_1_Y/B
+ sg13g2_nor2_1
Xbist_pattern_count\[3\]_sg13g2_dfrbpq_1_Q_D_sg13g2_nor3_1_Y bist_pattern_count\[4\]_sg13g2_and2_1_A/B
+ bist_pattern_count\[3\]_sg13g2_dfrbpq_1_Q/D bist_fault_sg13g2_dfrbpq_1_Q_D_sg13g2_nor3_1_Y/A
+ bist_pattern_count\[3\]_sg13g2_nor2_1_A/Y VDD VSS sg13g2_nor3_1
Xcycle_counter\[7\]_sg13g2_dfrbpq_1_Q_D_sg13g2_xnor2_1_Y_B_sg13g2_nand4_1_Y VDD cycle_counter\[7\]_sg13g2_dfrbpq_1_Q_D_sg13g2_xnor2_1_Y/B
+ cycle_counter\[5\]_sg13g2_dfrbpq_1_Q/Q cycle_counter\[6\]_sg13g2_dfrbpq_1_Q/Q VSS
+ bist_done_sg13g2_a22oi_1_B2/A1 cycle_counter\[4\]_sg13g2_dfrbpq_1_Q_D_sg13g2_xnor2_1_Y/B
+ sg13g2_nand4_1
Xserial_b\[7\]_sg13g2_dfrbpq_1_Q_D_sg13g2_mux2_1_X operation\[0\]_sg13g2_mux2_1_A0/A1
+ serial_b\[7\]_sg13g2_dfrbpq_1_Q/D ui_in[1] VDD VSS serial_b\[7\]_sg13g2_dfrbpq_1_Q/Q
+ sg13g2_mux2_1
Xclkbuf_4_9_0_clk clkbuf_4_9_0_clk/X VSS clkbuf_0_clk/X VDD sg13g2_buf_4
Xscan_reg\[47\]_sg13g2_dfrbpq_1_Q_D_sg13g2_a21oi_1_Y VDD VSS scan_out_sg13g2_a22oi_1_A1/B1
+ scan_reg\[48\]_sg13g2_inv_1_A/Y scan_reg\[47\]_sg13g2_o21ai_1_A1/Y scan_reg\[47\]_sg13g2_dfrbpq_1_Q/D
+ sg13g2_a21oi_1
Xbist_state\[1\]_sg13g2_a21oi_1_A1 VDD VSS bist_state\[1\]_sg13g2_a21oi_1_A1/A2 bist_state\[1\]_sg13g2_inv_1_A/A
+ bist_state\[1\]_sg13g2_a21oi_1_A1/B1 lfsr\[7\]_sg13g2_a22oi_1_A1/A2 sg13g2_a21oi_1
Xmisr\[7\]_sg13g2_dfrbpq_1_Q_D_sg13g2_a22oi_1_Y_B2_sg13g2_o21ai_1_Y_A2_sg13g2_a22oi_1_Y_A2_sg13g2_nand2_1_Y_B_sg13g2_and3_1_X
+ misr\[7\]_sg13g2_dfrbpq_1_Q_D_sg13g2_a22oi_1_Y_B2_sg13g2_o21ai_1_Y_A2_sg13g2_a22oi_1_Y_B1_sg13g2_mux2_1_X/A0
+ uio_in[3] VDD VSS uio_in[5] uio_in[4] sg13g2_and3_1
Xmisr\[5\]_sg13g2_dfrbpq_1_Q_D_sg13g2_o21ai_1_Y_B1_sg13g2_nand2_1_Y misr\[5\]_sg13g2_dfrbpq_1_Q_D_sg13g2_o21ai_1_Y/B1
+ VDD misr\[5\]_sg13g2_dfrbpq_1_Q/Q VSS misr\[7\]_sg13g2_dfrbpq_1_Q_D_sg13g2_a22oi_1_Y/A2
+ sg13g2_nand2_1
Xserial_b\[1\]_sg13g2_dfrbpq_1_Q VDD serial_b\[1\]_sg13g2_dfrbpq_1_Q/D serial_b\[1\]_sg13g2_xor2_1_A/A
+ clkbuf_5_16__f_clk/X VSS rst_n sg13g2_dfrbpq_1
Xoverflow_flag_sg13g2_dfrbpq_1_Q_D_sg13g2_inv_1_Y_A_sg13g2_o21ai_1_Y_B1_sg13g2_nand3_1_Y_A_sg13g2_nand2_1_Y_B_sg13g2_a21oi_1_Y_A2_sg13g2_o21ai_1_Y_B1_sg13g2_a22oi_1_B2_Y_sg13g2_nand4_1_C
+ VDD overflow_flag_sg13g2_dfrbpq_1_Q_D_sg13g2_inv_1_Y_A_sg13g2_o21ai_1_Y_B1_sg13g2_nand3_1_Y_A_sg13g2_nand2_1_Y_B_sg13g2_a21oi_1_Y_A2_sg13g2_o21ai_1_Y_B1_sg13g2_a22oi_1_B2_Y_sg13g2_nand4_1_C/Y
+ overflow_flag_sg13g2_dfrbpq_1_Q_D_sg13g2_inv_1_Y_A_sg13g2_o21ai_1_Y_B1_sg13g2_nand3_1_Y_A_sg13g2_nand2_1_Y_B_sg13g2_a21oi_1_Y_A2_sg13g2_o21ai_1_Y_B1_sg13g2_a22oi_1_B2_Y_sg13g2_nand4_1_C/B
+ overflow_flag_sg13g2_dfrbpq_1_Q_D_sg13g2_inv_1_Y_A_sg13g2_o21ai_1_Y_B1_sg13g2_nand3_1_Y_A_sg13g2_nand2_1_Y_B_sg13g2_a21oi_1_Y_A2_sg13g2_o21ai_1_Y_B1_sg13g2_a22oi_1_B2/Y
+ VSS carry_flag_sg13g2_o21ai_1_A1_B1_sg13g2_nand2_1_Y_A_sg13g2_nand3_1_Y_A_sg13g2_a21oi_1_B1_Y_sg13g2_a22oi_1_B2/Y
+ overflow_flag_sg13g2_dfrbpq_1_Q_D_sg13g2_inv_1_Y_A_sg13g2_o21ai_1_Y_B1_sg13g2_nand3_1_Y_A_sg13g2_nand2_1_Y_B_sg13g2_a21oi_1_Y_A2_sg13g2_o21ai_1_Y_B1_sg13g2_a22oi_1_B2_Y_sg13g2_nand4_1_C/D
+ sg13g2_nand4_1
Xbist_fault_sg13g2_nor2_1_B uio_in[0] VDD bist_fault_sg13g2_nor2_1_B/Y VSS bist_fault_sg13g2_nor2_1_B/B
+ sg13g2_nor2_1
Xscan_reg\[31\]_sg13g2_dfrbpq_1_Q_D_sg13g2_a21oi_1_Y VDD VSS scan_out_sg13g2_a22oi_1_A1/A2
+ scan_reg\[31\]_sg13g2_inv_1_A/Y scan_reg\[32\]_sg13g2_o21ai_1_A1/Y scan_reg\[31\]_sg13g2_dfrbpq_1_Q/D
+ sg13g2_a21oi_1
Xuo_out_sg13g2_dfrbpq_1_Q_3_D_sg13g2_o21ai_1_Y_B1_sg13g2_nand2_1_Y_B_sg13g2_a22oi_1_Y_A2_sg13g2_nand2_1_Y
+ uo_out_sg13g2_dfrbpq_1_Q_3_D_sg13g2_o21ai_1_Y_B1_sg13g2_nand2_1_Y_B_sg13g2_a22oi_1_Y/A2
+ VDD uio_in[0] VSS uo_out_sg13g2_dfrbpq_1_Q_3_D_sg13g2_o21ai_1_Y_B1_sg13g2_nand2_1_Y_B_sg13g2_a22oi_1_Y_B2_sg13g2_mux2_1_X/A0
+ sg13g2_nand2_1
Xmisr\[4\]_sg13g2_dfrbpq_1_Q_D_sg13g2_a22oi_1_Y_B2_sg13g2_o21ai_1_Y_A2_sg13g2_a21oi_1_Y_B1_sg13g2_nor3_1_Y
+ misr\[4\]_sg13g2_dfrbpq_1_Q_D_sg13g2_a22oi_1_Y_B2_sg13g2_o21ai_1_Y_A2_sg13g2_a21oi_1_Y_B1_sg13g2_nor3_1_Y/A
+ misr\[4\]_sg13g2_dfrbpq_1_Q_D_sg13g2_a22oi_1_Y_B2_sg13g2_o21ai_1_Y_A2_sg13g2_a21oi_1_Y/B1
+ uo_out_sg13g2_dfrbpq_1_Q_6_D_sg13g2_a21oi_1_Y_A2_sg13g2_a21o_1_X_B1_sg13g2_a221oi_1_Y/C1
+ misr\[4\]_sg13g2_dfrbpq_1_Q_D_sg13g2_a22oi_1_Y_B2_sg13g2_o21ai_1_Y_A2_sg13g2_a21oi_1_Y_B1_sg13g2_nor3_1_Y/C
+ VDD VSS sg13g2_nor3_1
Xscan_reg\[19\]_sg13g2_nor2_1_A scan_reg\[19\]_sg13g2_nor2_1_A/A VDD scan_reg\[19\]_sg13g2_nor2_1_A/Y
+ VSS scan_reg\[3\]_sg13g2_nor2_1_A/B sg13g2_nor2_1
Xbist_a\[7\]_sg13g2_dfrbpq_1_Q_D_sg13g2_o21ai_1_Y_A1_sg13g2_inv_1_Y bist_a\[7\]_sg13g2_dfrbpq_1_Q_D_sg13g2_o21ai_1_Y/A1
+ bist_a\[7\]_sg13g2_or2_1_A/A VSS VDD sg13g2_inv_1
Xmisr\[3\]_sg13g2_dfrbpq_1_Q_D_sg13g2_o21ai_1_Y VSS VDD misr\[3\]_sg13g2_dfrbpq_1_Q/D
+ misr\[3\]_sg13g2_dfrbpq_1_Q_D_sg13g2_o21ai_1_Y/B1 misr\[3\]_sg13g2_dfrbpq_1_Q_D_sg13g2_o21ai_1_Y/A2
+ misr\[6\]_sg13g2_dfrbpq_1_Q_D_sg13g2_o21ai_1_Y/A1 sg13g2_o21ai_1
Xlfsr\[6\]_sg13g2_mux2_1_A1 lfsr\[6\]_sg13g2_mux2_1_A1/A1 lfsr\[6\]_sg13g2_mux2_1_A1/X
+ lfsr\[7\]_sg13g2_nand2_1_A/B VDD VSS lfsr\[6\]_sg13g2_mux2_1_A1/A0 sg13g2_mux2_1
Xuo_out_sg13g2_dfrbpq_1_Q_D_sg13g2_a21oi_1_Y_B1_sg13g2_a21oi_1_Y_A1_sg13g2_nand3_1_Y_B_sg13g2_a221oi_1_Y_B1_sg13g2_xnor2_1_Y
+ uo_out_sg13g2_dfrbpq_1_Q_D_sg13g2_a21oi_1_Y_B1_sg13g2_a21oi_1_Y_A1_sg13g2_nand3_1_Y_B_sg13g2_a221oi_1_Y/B1
+ uo_out_sg13g2_dfrbpq_1_Q_D_sg13g2_a21oi_1_Y_B1_sg13g2_a21oi_1_Y_A1_sg13g2_nand3_1_Y_B_sg13g2_a221oi_1_Y_B1_sg13g2_xnor2_1_Y/B
+ VDD uo_out_sg13g2_dfrbpq_1_Q_D_sg13g2_a21oi_1_Y_B1_sg13g2_a21oi_1_Y_A1_sg13g2_nand3_1_Y_B_sg13g2_a221oi_1_Y_B1_sg13g2_xnor2_1_Y/A
+ VSS sg13g2_xnor2_1
Xserial_a\[5\]_sg13g2_dfrbpq_1_Q_D_sg13g2_mux2_1_X serial_b\[6\]_sg13g2_and2_1_A/B
+ serial_a\[5\]_sg13g2_dfrbpq_1_Q/D ui_in[1] VDD VSS serial_a\[5\]_sg13g2_dfrbpq_1_Q/Q
+ sg13g2_mux2_1
Xoverflow_flag_sg13g2_dfrbpq_1_Q_D_sg13g2_inv_1_Y_A_sg13g2_o21ai_1_Y_B1_sg13g2_nand3_1_Y_A_sg13g2_and4_1_A_X_sg13g2_nand3_1_B_C_sg13g2_a22oi_1_Y_A2_sg13g2_nor2_1_Y_B_sg13g2_a21oi_1_Y_B1_sg13g2_nor2b_1_Y
+ serial_b\[7\]_sg13g2_dfrbpq_1_Q/Q serial_a\[7\]_sg13g2_dfrbpq_1_Q/Q VDD carry_flag_sg13g2_o21ai_1_A1_B1_sg13g2_nand2_1_Y_A_sg13g2_nand3_1_Y_B_sg13g2_nand3_1_C_A_sg13g2_o21ai_1_B1_A2_sg13g2_nor3_1_Y/A
+ VSS sg13g2_nor2b_1
Xuio_out_sg13g2_nand2_1_Y_2 uio_out[2] VDD uio_out_sg13g2_nand2_1_Y_2/A VSS uio_out_sg13g2_nand2_1_Y_2/B
+ sg13g2_nand2_1
Xscan_reg\[50\]_sg13g2_inv_1_A scan_reg\[50\]_sg13g2_inv_1_A/Y scan_reg\[50\]_sg13g2_inv_1_A/A
+ VSS VDD sg13g2_inv_1
Xserial_opcode\[3\]_sg13g2_nor2_1_B serial_opcode\[2\]_sg13g2_inv_1_A/Y VDD serial_opcode\[3\]_sg13g2_nor2_1_B/Y
+ VSS serial_opcode\[3\]_sg13g2_nor2_1_B/B sg13g2_nor2_1
Xclkbuf_5_14__f_clk clkbuf_5_14__f_clk/X VSS clkbuf_4_7_0_clk/X VDD sg13g2_buf_4
Xoperation\[3\]_sg13g2_dfrbpq_1_Q_D_sg13g2_a21oi_1_Y VDD VSS ui_in[2] operation\[3\]_sg13g2_dfrbpq_1_Q_D_sg13g2_a21oi_1_Y/A1
+ operation\[3\]_sg13g2_nor2_1_A/Y operation\[3\]_sg13g2_dfrbpq_1_Q/D sg13g2_a21oi_1
Xscan_reg\[34\]_sg13g2_a22oi_1_B1 scan_reg\[34\]_sg13g2_a22oi_1_B1/Y ui_in[3] VDD
+ scan_reg\[34\]_sg13g2_inv_1_A/A misr\[1\]_sg13g2_inv_1_A/A VSS scan_out_sg13g2_a22oi_1_A1/B1
+ sg13g2_a22oi_1
Xmisr\[4\]_sg13g2_inv_1_A_Y_sg13g2_xnor2_1_A_B_sg13g2_o21ai_1_Y_B1_sg13g2_or2_1_X_A_sg13g2_nand3_1_Y_C_sg13g2_a21oi_1_Y_B1_sg13g2_a221oi_1_Y_B2_sg13g2_nand2b_1_Y
+ VSS bist_a\[7\]_sg13g2_dfrbpq_1_Q_D_sg13g2_o21ai_1_Y_A1_sg13g2_o21ai_1_A1_Y_sg13g2_nand2b_1_A_N_B_sg13g2_a21oi_1_Y/A1
+ misr\[4\]_sg13g2_inv_1_A_Y_sg13g2_xnor2_1_A_B_sg13g2_o21ai_1_Y_B1_sg13g2_or2_1_X_A_sg13g2_nand3_1_Y_C_sg13g2_a21oi_1_Y_B1_sg13g2_a221oi_1_Y/B2
+ bist_a\[7\]_sg13g2_dfrbpq_1_Q_D_sg13g2_o21ai_1_Y_A1_sg13g2_o21ai_1_A1_Y_sg13g2_nand2b_1_A_N_Y_sg13g2_a221oi_1_C1_B1_sg13g2_mux2_1_X/S
+ VDD sg13g2_nand2b_1
Xscan_reg\[36\]_sg13g2_dfrbpq_1_Q_D_sg13g2_o21ai_1_Y VSS VDD scan_reg\[36\]_sg13g2_dfrbpq_1_Q/D
+ scan_reg\[37\]_sg13g2_a22oi_1_B1/Y scan_reg\[41\]_sg13g2_nor2_1_A/B scan_reg\[36\]_sg13g2_inv_1_A/Y
+ sg13g2_o21ai_1
Xoperation\[0\]_sg13g2_dfrbpq_1_Q VDD operation\[0\]_sg13g2_mux2_1_A0/X operation\[0\]_sg13g2_mux2_1_A0/A0
+ clkbuf_5_22__f_clk/X VSS rst_n sg13g2_dfrbpq_1
Xmisr\[1\]_sg13g2_inv_1_A_Y_sg13g2_xnor2_1_A_B_sg13g2_o21ai_1_Y_B1_sg13g2_nand4_1_Y_D_sg13g2_or2_1_X
+ misr\[4\]_sg13g2_inv_1_A_Y_sg13g2_xnor2_1_A_B_sg13g2_o21ai_1_Y_A2_sg13g2_o21ai_1_Y/A1
+ VSS misr\[1\]_sg13g2_inv_1_A_Y_sg13g2_xnor2_1_A_B_sg13g2_o21ai_1_Y/A2 misr\[1\]_sg13g2_inv_1_A_Y_sg13g2_xnor2_1_A_B_sg13g2_o21ai_1_Y_B1_sg13g2_nand4_1_Y/D
+ VDD sg13g2_or2_1
Xscan_reg\[17\]_sg13g2_dfrbpq_1_Q_D_sg13g2_a21oi_1_Y VDD VSS scan_out_sg13g2_a22oi_1_A1/B1
+ scan_reg\[18\]_sg13g2_inv_1_A/Y scan_reg\[17\]_sg13g2_o21ai_1_A1_1/Y scan_reg\[17\]_sg13g2_dfrbpq_1_Q/D
+ sg13g2_a21oi_1
Xmisr\[0\]_sg13g2_dfrbpq_1_Q_D_sg13g2_a22oi_1_Y_B2_sg13g2_o21ai_1_Y_A2_sg13g2_a21oi_1_Y_B1_sg13g2_a21oi_1_Y_B1_sg13g2_o21ai_1_Y_B1_sg13g2_and2_1_X
+ misr\[0\]_sg13g2_dfrbpq_1_Q_D_sg13g2_a22oi_1_Y_B2_sg13g2_o21ai_1_Y_A2_sg13g2_a21oi_1_Y_B1_sg13g2_a21oi_1_Y_B1_sg13g2_o21ai_1_Y/B1
+ VSS VDD uo_out_sg13g2_dfrbpq_1_Q_3_D_sg13g2_o21ai_1_Y_B1_sg13g2_nand2_1_Y_B_sg13g2_a22oi_1_Y_B2_sg13g2_mux2_1_X/A0
+ uo_out_sg13g2_dfrbpq_1_Q_4_D_sg13g2_a21oi_1_Y_A2_sg13g2_a21o_1_X_A2_sg13g2_a21o_1_X/A1
+ sg13g2_and2_1
Xscan_reg\[10\]_sg13g2_dfrbpq_1_Q VDD scan_reg\[10\]_sg13g2_dfrbpq_1_Q/D scan_reg\[10\]_sg13g2_inv_1_A/A
+ clkload3/A VSS rst_n sg13g2_dfrbpq_1
Xscan_reg\[30\]_sg13g2_dfrbpq_1_Q VDD scan_reg\[30\]_sg13g2_dfrbpq_1_Q/D scan_reg\[30\]_sg13g2_dfrbpq_1_Q/Q
+ clkbuf_5_28__f_clk/X VSS rst_n sg13g2_dfrbpq_1
Xclkbuf_4_8_0_clk clkbuf_4_8_0_clk/X VSS clkbuf_0_clk/X VDD sg13g2_buf_4
Xoverflow_flag_sg13g2_dfrbpq_1_Q_D_sg13g2_inv_1_Y_A_sg13g2_o21ai_1_Y_B1_sg13g2_nand3_1_Y_A_sg13g2_and4_1_A_X_sg13g2_nand3_1_B_C_sg13g2_a22oi_1_Y_B1_sg13g2_xor2_1_X_B_sg13g2_nand4_1_B
+ VDD carry_flag_sg13g2_o21ai_1_A1_B1_sg13g2_nand2_1_Y_A_sg13g2_nand3_1_Y_B_sg13g2_nand3_1_C_Y_sg13g2_o21ai_1_B1_A2_sg13g2_nor3_1_Y_C_sg13g2_nor4_1_Y/C
+ overflow_flag_sg13g2_dfrbpq_1_Q_D_sg13g2_inv_1_Y_A_sg13g2_o21ai_1_Y_B1_sg13g2_nand3_1_Y_A_sg13g2_and4_1_A_X_sg13g2_nand3_1_B_C_sg13g2_a22oi_1_Y_B1_sg13g2_xor2_1_X/B
+ uo_out_sg13g2_dfrbpq_1_Q_5_D_sg13g2_a21oi_1_Y_A2_sg13g2_o21ai_1_Y_B1_sg13g2_or2_1_X_B_sg13g2_nand2_1_Y_B_sg13g2_a22oi_1_Y_B1_sg13g2_nand3_1_Y/B
+ VSS serial_b\[0\]_sg13g2_xnor2_1_B/Y uo_out_sg13g2_dfrbpq_1_Q_D_sg13g2_a21oi_1_Y_B1_sg13g2_a21oi_1_Y_A1_sg13g2_nand3_1_Y_B_sg13g2_a221oi_1_Y_B1_sg13g2_xnor2_1_Y/B
+ sg13g2_nand4_1
Xbist_a\[7\]_sg13g2_dfrbpq_1_Q_D_sg13g2_o21ai_1_Y_A1_sg13g2_nand2_1_A_Y_sg13g2_a221oi_1_A1_Y_sg13g2_o21ai_1_B1
+ VSS VDD misr\[7\]_sg13g2_dfrbpq_1_Q_D_sg13g2_a22oi_1_Y_B2_sg13g2_o21ai_1_Y_A2_sg13g2_a22oi_1_Y_A1_sg13g2_a21oi_1_Y/B1
+ bist_a\[7\]_sg13g2_dfrbpq_1_Q_D_sg13g2_o21ai_1_Y_A1_sg13g2_nand2_1_A_Y_sg13g2_a221oi_1_A1/Y
+ bist_a\[7\]_sg13g2_dfrbpq_1_Q_D_sg13g2_o21ai_1_Y_A1_sg13g2_nand2_1_A_Y_sg13g2_a221oi_1_A1_Y_sg13g2_o21ai_1_B1/A2
+ bist_a\[7\]_sg13g2_dfrbpq_1_Q_D_sg13g2_o21ai_1_Y_A1_sg13g2_nand2_1_A_Y_sg13g2_a221oi_1_A1_Y_sg13g2_o21ai_1_B1/A1
+ sg13g2_o21ai_1
Xcycle_counter\[7\]_sg13g2_dfrbpq_1_Q VDD cycle_counter\[7\]_sg13g2_dfrbpq_1_Q/D cycle_counter\[7\]_sg13g2_dfrbpq_1_Q/Q
+ clkbuf_5_14__f_clk/X VSS rst_n sg13g2_dfrbpq_1
Xscan_reg\[50\]_sg13g2_dfrbpq_1_Q VDD scan_reg\[50\]_sg13g2_dfrbpq_1_Q/D scan_reg\[50\]_sg13g2_inv_1_A/A
+ clkbuf_5_24__f_clk/X VSS rst_n sg13g2_dfrbpq_1
Xcarry_flag_sg13g2_o21ai_1_A1_B1_sg13g2_nand2_1_Y_A_sg13g2_nand3_1_Y_A_sg13g2_a21oi_1_B1_Y_sg13g2_a221oi_1_B2_C1_sg13g2_o21ai_1_Y_A2_sg13g2_a21oi_1_Y_A1_sg13g2_nand2b_1_A_N
+ VSS carry_flag_sg13g2_o21ai_1_A1_B1_sg13g2_nand2_1_Y_A_sg13g2_nand3_1_Y_A_sg13g2_a21oi_1_B1_Y_sg13g2_a221oi_1_B2_C1_sg13g2_o21ai_1_Y_A2_sg13g2_a21oi_1_Y/A1
+ carry_flag_sg13g2_o21ai_1_A1_B1_sg13g2_nand2_1_Y_A_sg13g2_nand3_1_Y_A_sg13g2_a21oi_1_B1_Y_sg13g2_a221oi_1_B2_C1_sg13g2_o21ai_1_Y_B1_sg13g2_a221oi_1_Y_C1_sg13g2_o21ai_1_Y/B1
+ overflow_flag_sg13g2_dfrbpq_1_Q_D_sg13g2_inv_1_Y_A_sg13g2_o21ai_1_Y_B1_sg13g2_nand3_1_Y_A_sg13g2_and4_1_A_C_sg13g2_o21ai_1_Y/A2
+ VDD sg13g2_nand2b_1
Xfault_counter\[1\]_sg13g2_dfrbpq_1_Q_D_sg13g2_xor2_1_X fault_counter\[1\]_sg13g2_dfrbpq_1_Q/D
+ VDD fault_counter\[1\]_sg13g2_dfrbpq_1_Q_D_sg13g2_xor2_1_X/B fault_counter\[1\]_sg13g2_dfrbpq_1_Q/Q
+ VSS sg13g2_xor2_1
Xlfsr\[1\]_sg13g2_a22oi_1_A1 lfsr\[1\]_sg13g2_a22oi_1_A1/Y lfsr\[7\]_sg13g2_a22oi_1_A1/A2
+ VDD lfsr\[7\]_sg13g2_a22oi_1_A1/B1 lfsr\[1\]_sg13g2_nand2_1_A/A VSS lfsr\[1\]_sg13g2_a22oi_1_A1/B2
+ sg13g2_a22oi_1
Xoperand_a\[5\]_sg13g2_dfrbpq_1_Q VDD operand_a\[5\]_sg13g2_mux2_1_A0/X operand_a\[5\]_sg13g2_mux2_1_A0/A0
+ clkbuf_5_21__f_clk/X VSS rst_n sg13g2_dfrbpq_1
Xuio_out_sg13g2_nand2_1_Y_3 uio_out[1] VDD uio_out_sg13g2_nand2_1_Y_3/A VSS uio_out_sg13g2_nand2_1_Y_3/B
+ sg13g2_nand2_1
Xoperand_b\[2\]_sg13g2_nor2_1_A operand_b\[2\]_sg13g2_nor2_1_A/A VDD operand_b\[2\]_sg13g2_nor2_1_A/Y
+ VSS ui_in[2] sg13g2_nor2_1
Xuo_out_sg13g2_dfrbpq_1_Q_5_D_sg13g2_a21oi_1_Y_A2_sg13g2_o21ai_1_Y_B1_sg13g2_or2_1_X_B_sg13g2_nand2_1_Y_B_sg13g2_a22oi_1_Y_B1_sg13g2_nand3_1_Y
+ VDD uo_out_sg13g2_dfrbpq_1_Q_5_D_sg13g2_a21oi_1_Y_A2_sg13g2_o21ai_1_Y_B1_sg13g2_or2_1_X_B_sg13g2_nand2_1_Y_B_sg13g2_a22oi_1_Y/B1
+ uo_out_sg13g2_dfrbpq_1_Q_5_D_sg13g2_a21oi_1_Y_A2_sg13g2_o21ai_1_Y_B1_sg13g2_or2_1_X_B_sg13g2_nand2_1_Y_B_sg13g2_a22oi_1_Y_B1_sg13g2_nand3_1_Y/B
+ uo_out_sg13g2_dfrbpq_1_Q_6_D_sg13g2_a21oi_1_Y_A2_sg13g2_a21o_1_X_A2_sg13g2_and2_1_X_B_sg13g2_a22oi_1_Y_B2_sg13g2_and2_1_X/A
+ serial_b\[4\]_sg13g2_nand2_1_A/Y VSS sg13g2_nand3_1
Xcarry_flag_sg13g2_o21ai_1_A1_B1_sg13g2_nand2_1_Y_A_sg13g2_nand3_1_Y_B_sg13g2_nand3_1_Y
+ VDD carry_flag_sg13g2_o21ai_1_A1_B1_sg13g2_nand2_1_Y_A_sg13g2_nand3_1_Y/B serial_b\[6\]_sg13g2_nand2b_1_A_N/Y
+ carry_flag_sg13g2_o21ai_1_A1_B1_sg13g2_nand2_1_Y_A_sg13g2_nand3_1_Y_B_sg13g2_nand3_1_Y/C
+ carry_flag_sg13g2_o21ai_1_A1_B1_sg13g2_nand2_1_Y_A_sg13g2_nand3_1_Y_B_sg13g2_nand3_1_Y/A
+ VSS sg13g2_nand3_1
Xlfsr\[7\]_sg13g2_nand2_1_A lfsr\[7\]_sg13g2_nand2_1_A/Y VDD lfsr\[7\]_sg13g2_xnor2_1_B/B
+ VSS lfsr\[7\]_sg13g2_nand2_1_A/B sg13g2_nand2_1
Xnegative_flag_sg13g2_dfrbpq_1_Q_D_sg13g2_a21oi_1_Y_A2_sg13g2_o21ai_1_Y_A2_sg13g2_o21ai_1_Y_A1_sg13g2_nand2_1_Y
+ negative_flag_sg13g2_dfrbpq_1_Q_D_sg13g2_a21oi_1_Y_A2_sg13g2_o21ai_1_Y_A2_sg13g2_o21ai_1_Y/A1
+ VDD uio_in[2] VSS uio_in[1] sg13g2_nand2_1
Xscan_reg\[2\]_sg13g2_dfrbpq_1_Q VDD scan_reg\[2\]_sg13g2_dfrbpq_1_Q/D scan_reg\[2\]_sg13g2_inv_1_A/A
+ clkbuf_5_4__f_clk/X VSS rst_n sg13g2_dfrbpq_1
Xbist_fault_sg13g2_nor2_1_B_Y_sg13g2_o21ai_1_A2 VSS VDD bist_fault_sg13g2_nor2_1_B_Y_sg13g2_o21ai_1_A2/Y
+ bist_fault_sg13g2_nor2_1_B_Y_sg13g2_o21ai_1_A2/B1 bist_fault_sg13g2_nor2_1_B/Y bist_fault_sg13g2_nor2_1_B_Y_sg13g2_o21ai_1_A2/A1
+ sg13g2_o21ai_1
Xclkbuf_5_20__f_clk clkbuf_5_20__f_clk/X VSS clkbuf_4_10_0_clk/X VDD sg13g2_buf_4
Xscan_reg\[46\]_sg13g2_inv_1_A scan_reg\[46\]_sg13g2_inv_1_A/Y scan_reg\[46\]_sg13g2_inv_1_A/A
+ VSS VDD sg13g2_inv_1
Xbist_a\[7\]_sg13g2_dfrbpq_1_Q_D_sg13g2_o21ai_1_Y_A1_sg13g2_o21ai_1_A1_Y_sg13g2_nand2b_1_A_N_Y_sg13g2_a221oi_1_C1
+ bist_a\[7\]_sg13g2_dfrbpq_1_Q_D_sg13g2_o21ai_1_Y_A1_sg13g2_o21ai_1_A1_Y_sg13g2_nand2b_1_A_N/Y
+ misr\[0\]_sg13g2_dfrbpq_1_Q_D_sg13g2_a22oi_1_Y_B2_sg13g2_o21ai_1_Y_A2_sg13g2_a21oi_1_Y_A2_sg13g2_nor2b_1_Y/B_N
+ misr\[4\]_sg13g2_inv_1_A_Y_sg13g2_xnor2_1_A_B_sg13g2_o21ai_1_Y_A1_sg13g2_a21oi_1_Y_A2_sg13g2_a21oi_1_Y/A1
+ bist_a\[7\]_sg13g2_dfrbpq_1_Q_D_sg13g2_o21ai_1_Y_A1_sg13g2_o21ai_1_A1_B1_sg13g2_nand4_1_C_Y_sg13g2_a221oi_1_C1/A2
+ misr\[4\]_sg13g2_inv_1_A_Y_sg13g2_xnor2_1_A_B_sg13g2_o21ai_1_Y_A1_sg13g2_a21oi_1_Y_A2_sg13g2_a21oi_1_Y/A2
+ VDD bist_a\[7\]_sg13g2_dfrbpq_1_Q_D_sg13g2_o21ai_1_Y_A1_sg13g2_nand2_1_A_Y_sg13g2_a221oi_1_A1/C1
+ VSS sg13g2_a221oi_1
Xuo_out_sg13g2_dfrbpq_1_Q_3_D_sg13g2_o21ai_1_Y_B1_sg13g2_nand2_1_Y_B_sg13g2_a22oi_1_Y_A1_sg13g2_a221oi_1_Y_C1_sg13g2_or4_1_X_D_sg13g2_nor3_1_Y
+ serial_b\[0\]_sg13g2_xnor2_1_B/Y uo_out_sg13g2_dfrbpq_1_Q_3_D_sg13g2_o21ai_1_Y_B1_sg13g2_nand2_1_Y_B_sg13g2_a22oi_1_Y_A1_sg13g2_a221oi_1_Y_C1_sg13g2_or4_1_X/D
+ uo_out_sg13g2_dfrbpq_1_Q_3_D_sg13g2_o21ai_1_Y_B1_sg13g2_nand2_1_Y_B_sg13g2_a22oi_1_Y_A1_sg13g2_a221oi_1_Y_C1_sg13g2_or4_1_X_D_sg13g2_nor3_1_Y/B
+ carry_flag_sg13g2_o21ai_1_A1_B1_sg13g2_nand2_1_Y_A_sg13g2_nand3_1_Y_B_sg13g2_nand3_1_Y_A_sg13g2_nor3_1_A/Y
+ VDD VSS sg13g2_nor3_1
Xoperand_a\[3\]_sg13g2_mux2_1_A0 serial_a\[3\]_sg13g2_dfrbpq_1_Q/Q operand_a\[3\]_sg13g2_mux2_1_A0/X
+ ui_in[2] VDD VSS operand_a\[3\]_sg13g2_mux2_1_A0/A0 sg13g2_mux2_1
Xoverflow_flag_sg13g2_dfrbpq_1_Q_D_sg13g2_inv_1_Y_A_sg13g2_o21ai_1_Y_B1_sg13g2_nand3_1_Y_C_sg13g2_a21oi_1_Y_A1_sg13g2_o21ai_1_A2_B1_sg13g2_o21ai_1_A1_Y_sg13g2_nor2_1_B_Y_sg13g2_o21ai_1_B1_A1_sg13g2_nand2_1_Y
+ overflow_flag_sg13g2_dfrbpq_1_Q_D_sg13g2_inv_1_Y_A_sg13g2_o21ai_1_Y_B1_sg13g2_nand3_1_Y_C_sg13g2_a21oi_1_Y_A1_sg13g2_o21ai_1_A2_B1_sg13g2_o21ai_1_A1_Y_sg13g2_nor2_1_B_Y_sg13g2_o21ai_1_B1/A1
+ VDD serial_opcode\[1\]_sg13g2_nor2b_1_A/Y VSS serial_opcode\[2\]_sg13g2_nor2_1_A/Y
+ sg13g2_nand2_1
Xserial_opcode\[3\]_sg13g2_nand2_1_B serial_opcode\[3\]_sg13g2_nand2_1_B/Y VDD serial_opcode\[2\]_sg13g2_inv_1_A/Y
+ VSS serial_opcode\[3\]_sg13g2_nor2_1_B/B sg13g2_nand2_1
Xbist_a\[7\]_sg13g2_dfrbpq_1_Q_D_sg13g2_o21ai_1_Y_A1_sg13g2_nand2_1_A_Y_sg13g2_a221oi_1_B2_A2_sg13g2_xnor2_1_Y_B_sg13g2_and2_1_X_A_sg13g2_nand2_1_Y
+ bist_a\[7\]_sg13g2_dfrbpq_1_Q_D_sg13g2_o21ai_1_Y_A1_sg13g2_nand2_1_A_Y_sg13g2_a221oi_1_B2_A2_sg13g2_xnor2_1_Y_B_sg13g2_and2_1_X/A
+ VDD bist_a\[2\]_sg13g2_dfrbpq_1_Q/Q VSS lfsr\[6\]_sg13g2_mux2_1_A1/A0 sg13g2_nand2_1
Xmisr\[1\]_sg13g2_dfrbpq_1_Q_D_sg13g2_a22oi_1_Y_B2_sg13g2_o21ai_1_Y_A2_sg13g2_a22oi_1_Y_A2_sg13g2_and2_1_X
+ misr\[1\]_sg13g2_dfrbpq_1_Q_D_sg13g2_a22oi_1_Y_B2_sg13g2_o21ai_1_Y_A2_sg13g2_a22oi_1_Y/A2
+ VSS VDD misr\[1\]_sg13g2_dfrbpq_1_Q_D_sg13g2_a22oi_1_Y_B2_sg13g2_o21ai_1_Y_A2_sg13g2_a22oi_1_Y_A2_sg13g2_and2_1_X/B
+ misr\[1\]_sg13g2_dfrbpq_1_Q_D_sg13g2_a22oi_1_Y_B2_sg13g2_o21ai_1_Y_A2_sg13g2_a22oi_1_Y_A2_sg13g2_and2_1_X/A
+ sg13g2_and2_1
Xscan_reg\[32\]_sg13g2_nor2_1_A scan_reg\[32\]_sg13g2_nor2_1_A/A VDD scan_reg\[32\]_sg13g2_nor2_1_A/Y
+ VSS scan_reg\[41\]_sg13g2_nor2_1_A/B sg13g2_nor2_1
Xfault_counter\[4\]_sg13g2_dfrbpq_1_Q VDD fault_counter\[4\]_sg13g2_dfrbpq_1_Q/D misr\[4\]_sg13g2_a22oi_1_B2/A1
+ clkbuf_5_11__f_clk/X VSS rst_n sg13g2_dfrbpq_1
Xzero_flag_sg13g2_dfrbpq_1_Q_D_sg13g2_o21ai_1_Y_A2_sg13g2_nand4_1_Y_D_sg13g2_a21oi_1_Y
+ VDD VSS uo_out_sg13g2_dfrbpq_1_Q_2_D_sg13g2_o21ai_1_Y_B1_sg13g2_nand3_1_Y/C uo_out_sg13g2_dfrbpq_1_Q_2_D_sg13g2_o21ai_1_Y_B1_sg13g2_nand3_1_Y/B
+ uo_out_sg13g2_dfrbpq_1_Q_3_D_sg13g2_o21ai_1_Y_B1_sg13g2_nand2_1_Y/B zero_flag_sg13g2_dfrbpq_1_Q_D_sg13g2_o21ai_1_Y_A2_sg13g2_nand4_1_Y/D
+ sg13g2_a21oi_1
Xbist_pattern_count\[0\]_sg13g2_dfrbpq_1_Q_D_sg13g2_a21oi_1_Y_B1_sg13g2_a21oi_1_Y
+ VDD VSS lfsr\[7\]_sg13g2_a22oi_1_A1/B1 bist_state\[2\]_sg13g2_dfrbpq_1_Q_D_sg13g2_a21o_1_X/A2
+ bist_pattern_count\[1\]_sg13g2_and3_1_A/B bist_pattern_count\[0\]_sg13g2_dfrbpq_1_Q_D_sg13g2_a21oi_1_Y/B1
+ sg13g2_a21oi_1
Xmisr\[1\]_sg13g2_inv_1_A_Y_sg13g2_xnor2_1_A_B_sg13g2_o21ai_1_Y_A2_sg13g2_nand3_1_Y_B_sg13g2_nor3_1_Y_B_sg13g2_a21oi_1_B1_A2_sg13g2_nor2b_1_Y
+ misr\[1\]_sg13g2_inv_1_A_Y_sg13g2_xnor2_1_A_B_sg13g2_o21ai_1_Y_A2_sg13g2_nand3_1_Y_B_sg13g2_nor3_1_Y_B_sg13g2_a21oi_1_B1_A2_sg13g2_nor2b_1_Y/A
+ bist_a\[7\]_sg13g2_dfrbpq_1_Q_D_sg13g2_o21ai_1_Y_A1_sg13g2_nand2_1_A_Y_sg13g2_a221oi_1_B2/A1
+ VDD misr\[1\]_sg13g2_inv_1_A_Y_sg13g2_xnor2_1_A_B_sg13g2_o21ai_1_Y_A2_sg13g2_nand3_1_Y_B_sg13g2_nor3_1_Y_B_sg13g2_a21oi_1_B1/A2
+ VSS sg13g2_nor2b_1
Xscan_reg\[45\]_sg13g2_nor2_1_A scan_reg\[45\]_sg13g2_nor2_1_A/A VDD scan_reg\[45\]_sg13g2_nor2_1_A/Y
+ VSS scan_reg\[3\]_sg13g2_nor2_1_A/B sg13g2_nor2_1
Xscan_reg\[27\]_sg13g2_a22oi_1_B1 scan_reg\[27\]_sg13g2_a22oi_1_B1/Y uo_out[7] VDD
+ scan_reg\[27\]_sg13g2_nor2_1_A/A ui_in[3] VSS scan_out_sg13g2_a22oi_1_A1/A2 sg13g2_a22oi_1
Xmisr\[0\]_sg13g2_dfrbpq_1_Q_D_sg13g2_a22oi_1_Y_B2_sg13g2_o21ai_1_Y_A2_sg13g2_a21oi_1_Y_B1_sg13g2_a21oi_1_Y_B1_sg13g2_o21ai_1_Y
+ VSS VDD misr\[0\]_sg13g2_dfrbpq_1_Q_D_sg13g2_a22oi_1_Y_B2_sg13g2_o21ai_1_Y_A2_sg13g2_a21oi_1_Y_B1_sg13g2_a21oi_1_Y/B1
+ misr\[0\]_sg13g2_dfrbpq_1_Q_D_sg13g2_a22oi_1_Y_B2_sg13g2_o21ai_1_Y_A2_sg13g2_a21oi_1_Y_B1_sg13g2_a21oi_1_Y_B1_sg13g2_o21ai_1_Y/B1
+ negative_flag_sg13g2_dfrbpq_1_Q_D_sg13g2_a21oi_1_Y_A2_sg13g2_o21ai_1_Y_A2_sg13g2_o21ai_1_Y/A1
+ misr\[7\]_sg13g2_dfrbpq_1_Q_D_sg13g2_a22oi_1_Y_B2_sg13g2_o21ai_1_Y_A2_sg13g2_a22oi_1_Y/A1
+ sg13g2_o21ai_1
Xserial_a\[4\]_sg13g2_dfrbpq_1_Q VDD serial_a\[4\]_sg13g2_dfrbpq_1_Q/D serial_b\[4\]_sg13g2_nand2_1_A/B
+ clkload3/A VSS rst_n sg13g2_dfrbpq_1
Xmisr\[6\]_sg13g2_dfrbpq_1_Q_D_sg13g2_o21ai_1_Y_A2_sg13g2_xnor2_1_Y_B_sg13g2_a22oi_1_Y_A1_sg13g2_and4_1_X_D_sg13g2_a221oi_1_Y
+ misr\[6\]_sg13g2_dfrbpq_1_Q_D_sg13g2_o21ai_1_Y_A2_sg13g2_xnor2_1_Y_B_sg13g2_a22oi_1_Y_A1_sg13g2_and4_1_X_D_sg13g2_a221oi_1_Y/C1
+ misr\[6\]_sg13g2_dfrbpq_1_Q_D_sg13g2_o21ai_1_Y_A2_sg13g2_xnor2_1_Y_B_sg13g2_a22oi_1_Y_A1_sg13g2_and4_1_X/D
+ bist_a\[7\]_sg13g2_or2_1_A/A misr\[3\]_sg13g2_dfrbpq_1_Q_D_sg13g2_o21ai_1_Y_A2_sg13g2_xnor2_1_Y_B_sg13g2_a22oi_1_Y_A2_sg13g2_a21oi_1_Y/A2
+ bist_a\[7\]_sg13g2_dfrbpq_1_Q_D_sg13g2_o21ai_1_Y_A1_sg13g2_nand2_1_A_Y_sg13g2_a221oi_1_A1/B1
+ VDD bist_a\[5\]_sg13g2_dfrbpq_1_Q/Q VSS sg13g2_a221oi_1
Xbist_a\[7\]_sg13g2_dfrbpq_1_Q_D_sg13g2_o21ai_1_Y_A1_sg13g2_nand2_1_A_Y_sg13g2_a221oi_1_B2_A2_sg13g2_xnor2_1_Y_A_sg13g2_and2_1_X_B_sg13g2_nand2_1_Y
+ bist_a\[7\]_sg13g2_dfrbpq_1_Q_D_sg13g2_o21ai_1_Y_A1_sg13g2_nand2_1_A_Y_sg13g2_a221oi_1_B2_A2_sg13g2_xnor2_1_Y_A_sg13g2_and2_1_X/B
+ VDD bist_a\[7\]_sg13g2_or2_1_A/A VSS bist_a\[7\]_sg13g2_or2_1_A/B sg13g2_nand2_1
Xbist_a\[5\]_sg13g2_dfrbpq_1_Q_D_sg13g2_mux2_1_X lfsr\[5\]_sg13g2_dfrbpq_1_Q/Q bist_a\[5\]_sg13g2_dfrbpq_1_Q/D
+ lfsr\[7\]_sg13g2_nand2_1_A/B VDD VSS bist_a\[5\]_sg13g2_dfrbpq_1_Q/Q sg13g2_mux2_1
Xbist_state\[2\]_sg13g2_dfrbpq_1_Q VDD bist_state\[2\]_sg13g2_dfrbpq_1_Q/D lfsr\[7\]_sg13g2_nand2_1_A/B
+ clkbuf_5_2__f_clk/X VSS rst_n sg13g2_dfrbpq_1
Xfault_counter\[1\]_sg13g2_dfrbpq_1_Q_D_sg13g2_xor2_1_X_B_sg13g2_nor2_1_Y scan_reg\[42\]_sg13g2_dfrbpq_1_Q_D_sg13g2_a221oi_1_Y/A1
+ VDD fault_counter\[1\]_sg13g2_dfrbpq_1_Q_D_sg13g2_xor2_1_X/B VSS bist_fault_sg13g2_o21ai_1_A2/Y
+ sg13g2_nor2_1
Xbist_a\[3\]_sg13g2_dfrbpq_1_Q VDD bist_a\[3\]_sg13g2_dfrbpq_1_Q/D bist_a\[7\]_sg13g2_or2_1_A/B
+ clkload0/A VSS rst_n sg13g2_dfrbpq_1
Xuo_out_sg13g2_dfrbpq_1_Q_3_D_sg13g2_o21ai_1_Y_A1_sg13g2_inv_1_Y uo_out_sg13g2_dfrbpq_1_Q_3_D_sg13g2_o21ai_1_Y/A1
+ uo_out[0] VSS VDD sg13g2_inv_1
Xserial_b\[6\]_sg13g2_nand2_1_A serial_b\[6\]_sg13g2_nand2_1_A/Y VDD serial_b\[6\]_sg13g2_and2_1_A/A
+ VSS serial_b\[6\]_sg13g2_and2_1_A/B sg13g2_nand2_1
Xoverflow_flag_sg13g2_dfrbpq_1_Q_D_sg13g2_inv_1_Y_A_sg13g2_o21ai_1_Y_B1_sg13g2_nand3_1_Y_A_sg13g2_and4_1_A_D_sg13g2_a221oi_1_Y_A2_sg13g2_o21ai_1_Y
+ VSS VDD overflow_flag_sg13g2_dfrbpq_1_Q_D_sg13g2_inv_1_Y_A_sg13g2_o21ai_1_Y_B1_sg13g2_nand3_1_Y_A_sg13g2_and4_1_A_D_sg13g2_a221oi_1_Y/A2
+ overflow_flag_sg13g2_dfrbpq_1_Q_D_sg13g2_inv_1_Y_A_sg13g2_o21ai_1_Y_B1_sg13g2_nand3_1_Y_A_sg13g2_and4_1_A_D_sg13g2_a221oi_1_Y_A2_sg13g2_o21ai_1_Y/B1
+ serial_opcode\[3\]_sg13g2_nand2_1_B/Y serial_opcode\[1\]_sg13g2_nand2b_1_A_N/Y sg13g2_o21ai_1
Xclkbuf_5_1__f_clk clkload0/A VSS clkbuf_4_0_0_clk/X VDD sg13g2_buf_4
Xscan_reg\[24\]_sg13g2_dfrbpq_1_Q_D_sg13g2_a221oi_1_Y scan_reg\[25\]_sg13g2_nor2_1_A/Y
+ scan_reg\[24\]_sg13g2_dfrbpq_1_Q/D scan_out_sg13g2_a22oi_1_A1/A2 scan_reg\[24\]_sg13g2_inv_1_A/Y
+ scan_reg\[24\]_sg13g2_dfrbpq_1_Q_D_sg13g2_a221oi_1_Y/A2 VDD ui_in[3] VSS sg13g2_a221oi_1
Xuo_out_sg13g2_dfrbpq_1_Q_5_D_sg13g2_a21oi_1_Y_A2_sg13g2_o21ai_1_Y_B1_sg13g2_or2_1_X_B_sg13g2_nand2_1_Y
+ uo_out_sg13g2_dfrbpq_1_Q_5_D_sg13g2_a21oi_1_Y_A2_sg13g2_o21ai_1_Y_B1_sg13g2_or2_1_X/B
+ VDD uo_out_sg13g2_dfrbpq_1_Q_5_D_sg13g2_a21oi_1_Y_A2_sg13g2_o21ai_1_Y_B1_sg13g2_or2_1_X_B_sg13g2_nand2_1_Y/A
+ VSS uo_out_sg13g2_dfrbpq_1_Q_5_D_sg13g2_a21oi_1_Y_A2_sg13g2_o21ai_1_Y_B1_sg13g2_or2_1_X_B_sg13g2_nand2_1_Y/B
+ sg13g2_nand2_1
Xmisr\[0\]_sg13g2_dfrbpq_1_Q_D_sg13g2_a22oi_1_Y misr\[0\]_sg13g2_dfrbpq_1_Q/D misr\[7\]_sg13g2_dfrbpq_1_Q_D_sg13g2_a22oi_1_Y/A2
+ VDD bist_state\[3\]_sg13g2_nor2_1_A/Y misr\[0\]_sg13g2_dfrbpq_1_Q_D_sg13g2_a22oi_1_Y/A1
+ VSS misr\[0\]_sg13g2_dfrbpq_1_Q_D_sg13g2_a22oi_1_Y/B2 sg13g2_a22oi_1
Xuio_out_sg13g2_nand2_1_Y_4 uio_out[0] VDD uio_out_sg13g2_nand2_1_Y_4/A VSS uio_out_sg13g2_nand2_1_Y_4/B
+ sg13g2_nand2_1
Xcarry_flag_sg13g2_dfrbpq_1_Q VDD carry_flag_sg13g2_dfrbpq_1_Q/D misr\[1\]_sg13g2_a22oi_1_B2/A1
+ clkbuf_5_28__f_clk/X VSS rst_n sg13g2_dfrbpq_1
Xbist_a\[2\]_sg13g2_dfrbpq_1_Q_D_sg13g2_o21ai_1_Y_A1_sg13g2_inv_1_Y bist_a\[2\]_sg13g2_dfrbpq_1_Q_D_sg13g2_o21ai_1_Y/A1
+ bist_a\[2\]_sg13g2_dfrbpq_1_Q/Q VSS VDD sg13g2_inv_1
Xfault_counter\[5\]_sg13g2_dfrbpq_1_Q_D_sg13g2_and2_1_X fault_counter\[5\]_sg13g2_dfrbpq_1_Q/D
+ VSS VDD fault_counter\[5\]_sg13g2_dfrbpq_1_Q_D_sg13g2_and2_1_X/B fault_counter\[5\]_sg13g2_dfrbpq_1_Q_D_sg13g2_and2_1_X/A
+ sg13g2_and2_1
Xscan_reg\[37\]_sg13g2_inv_1_A scan_reg\[37\]_sg13g2_inv_1_A/Y scan_reg\[37\]_sg13g2_inv_1_A/A
+ VSS VDD sg13g2_inv_1
Xmisr\[1\]_sg13g2_inv_1_A_Y_sg13g2_xnor2_1_A_B_sg13g2_o21ai_1_Y_A2_sg13g2_nand3_1_Y_B_sg13g2_nor3_1_Y_B_sg13g2_a21oi_1_Y_B1_sg13g2_nor2_1_Y
+ lfsr\[6\]_sg13g2_mux2_1_A1/A0 VDD misr\[1\]_sg13g2_inv_1_A_Y_sg13g2_xnor2_1_A_B_sg13g2_o21ai_1_Y_A2_sg13g2_nand3_1_Y_B_sg13g2_nor3_1_Y_B_sg13g2_a21oi_1_Y/B1
+ VSS bist_a\[7\]_sg13g2_dfrbpq_1_Q_D_sg13g2_o21ai_1_Y_A1_sg13g2_o21ai_1_A1_B1_sg13g2_a21oi_1_Y/A2
+ sg13g2_nor2_1
Xscan_reg\[23\]_sg13g2_dfrbpq_1_Q VDD scan_reg\[23\]_sg13g2_dfrbpq_1_Q/D scan_reg\[23\]_sg13g2_nor2_1_A/A
+ clkbuf_5_31__f_clk/X VSS rst_n sg13g2_dfrbpq_1
Xclkbuf_4_7_0_clk clkbuf_4_7_0_clk/X VSS clkbuf_0_clk/X VDD sg13g2_buf_4
Xscan_reg\[19\]_sg13g2_o21ai_1_A1 VSS VDD scan_reg\[19\]_sg13g2_o21ai_1_A1/Y scan_reg\[19\]_sg13g2_o21ai_1_A1/B1
+ scan_reg\[41\]_sg13g2_nor2_1_A/B scan_reg\[19\]_sg13g2_nor2_1_A/A sg13g2_o21ai_1
Xuo_out_sg13g2_dfrbpq_1_Q_D_sg13g2_a21oi_1_Y_B1_sg13g2_a21oi_1_Y_A2_sg13g2_nand3b_1_Y_A_N_sg13g2_nand2b_1_Y
+ VSS uo_out_sg13g2_dfrbpq_1_Q_D_sg13g2_a21oi_1_Y_B1_sg13g2_a21oi_1_Y_A1_sg13g2_nand3_1_Y/C
+ uo_out_sg13g2_dfrbpq_1_Q_D_sg13g2_a21oi_1_Y_B1_sg13g2_a21oi_1_Y_A2_sg13g2_nand3b_1_Y/A_N
+ misr\[1\]_sg13g2_inv_1_A_Y_sg13g2_xnor2_1_A_B_sg13g2_o21ai_1_Y_B1_sg13g2_nand4_1_Y/A
+ VDD sg13g2_nand2b_1
Xmisr\[4\]_sg13g2_inv_1_A_Y_sg13g2_xnor2_1_A_B_sg13g2_o21ai_1_Y VSS VDD misr\[4\]_sg13g2_inv_1_A_Y_sg13g2_xnor2_1_A/B
+ misr\[4\]_sg13g2_inv_1_A_Y_sg13g2_xnor2_1_A_B_sg13g2_o21ai_1_Y/B1 misr\[4\]_sg13g2_inv_1_A_Y_sg13g2_xnor2_1_A_B_sg13g2_o21ai_1_Y/A2
+ misr\[4\]_sg13g2_inv_1_A_Y_sg13g2_xnor2_1_A_B_sg13g2_o21ai_1_Y/A1 sg13g2_o21ai_1
Xscan_reg\[43\]_sg13g2_dfrbpq_1_Q VDD scan_reg\[43\]_sg13g2_dfrbpq_1_Q/D scan_reg\[43\]_sg13g2_nor2_1_A/A
+ clkbuf_5_8__f_clk/X VSS rst_n sg13g2_dfrbpq_1
Xuo_out_sg13g2_dfrbpq_1_Q_1_D_sg13g2_a21oi_1_Y_A2_sg13g2_o21ai_1_Y_A2_sg13g2_o21ai_1_Y
+ VSS VDD uo_out_sg13g2_dfrbpq_1_Q_1_D_sg13g2_a21oi_1_Y_A2_sg13g2_o21ai_1_Y/A2 uo_out_sg13g2_dfrbpq_1_Q_4_D_sg13g2_a21oi_1_Y_A2_sg13g2_a21o_1_X_A2_sg13g2_a21o_1_X/A1
+ uo_out_sg13g2_dfrbpq_1_Q_1_D_sg13g2_a21oi_1_Y_A2_sg13g2_o21ai_1_Y_A2_sg13g2_o21ai_1_Y/A2
+ uo_out_sg13g2_dfrbpq_1_Q_1_D_sg13g2_a21oi_1_Y_A2_sg13g2_o21ai_1_Y_B1_sg13g2_nand2b_1_Y/B
+ sg13g2_o21ai_1
Xmisr\[4\]_sg13g2_inv_1_A_Y_sg13g2_xnor2_1_A_B_sg13g2_o21ai_1_Y_A1_sg13g2_a21oi_1_Y_A2_sg13g2_a21oi_1_Y_A2_sg13g2_mux2_1_X
+ bist_a\[0\]_sg13g2_dfrbpq_1_Q/Q misr\[4\]_sg13g2_inv_1_A_Y_sg13g2_xnor2_1_A_B_sg13g2_o21ai_1_Y_A1_sg13g2_a21oi_1_Y_A2_sg13g2_a21oi_1_Y/A2
+ misr\[4\]_sg13g2_inv_1_A_Y_sg13g2_xnor2_1_A_B_sg13g2_o21ai_1_Y_A1_sg13g2_a21oi_1_Y_A2_sg13g2_a21oi_1_Y_A2_sg13g2_mux2_1_X/S
+ VDD VSS bist_a\[4\]_sg13g2_dfrbpq_1_Q/Q sg13g2_mux2_1
Xserial_a\[0\]_sg13g2_dfrbpq_1_Q_D_sg13g2_o21ai_1_Y VSS VDD serial_a\[0\]_sg13g2_dfrbpq_1_Q/D
+ serial_a\[0\]_sg13g2_dfrbpq_1_Q_D_sg13g2_o21ai_1_Y/B1 ui_in[1] serial_a\[0\]_sg13g2_dfrbpq_1_Q_D_sg13g2_o21ai_1_Y/A1
+ sg13g2_o21ai_1
Xmisr\[4\]_sg13g2_inv_1_A_Y_sg13g2_xnor2_1_A_B_sg13g2_o21ai_1_Y_A1_sg13g2_a21oi_1_Y_A2_sg13g2_a21oi_1_Y_A2_sg13g2_mux2_1_X_S_sg13g2_nand2_1_Y
+ misr\[4\]_sg13g2_inv_1_A_Y_sg13g2_xnor2_1_A_B_sg13g2_o21ai_1_Y_A1_sg13g2_a21oi_1_Y_A2_sg13g2_a21oi_1_Y_A2_sg13g2_mux2_1_X/S
+ VDD bist_a\[7\]_sg13g2_dfrbpq_1_Q_D_sg13g2_o21ai_1_Y_A1_sg13g2_o21ai_1_A1_Y_sg13g2_nand2b_1_A_N_Y_sg13g2_a221oi_1_C1_B1_sg13g2_mux2_1_X/S
+ VSS misr\[4\]_sg13g2_inv_1_A_Y_sg13g2_xnor2_1_A_B_sg13g2_o21ai_1_Y_A1_sg13g2_a21oi_1_Y_A2_sg13g2_a21oi_1_Y_A2_sg13g2_mux2_1_X_S_sg13g2_nand2_1_Y/B
+ sg13g2_nand2_1
Xserial_b\[7\]_sg13g2_dfrbpq_1_Q VDD serial_b\[7\]_sg13g2_dfrbpq_1_Q/D serial_b\[7\]_sg13g2_dfrbpq_1_Q/Q
+ clkload3/A VSS rst_n sg13g2_dfrbpq_1
Xuo_out_sg13g2_dfrbpq_1_Q_6_D_sg13g2_a21oi_1_Y_A2_sg13g2_a21o_1_X_A2_sg13g2_and2_1_X_A_sg13g2_a221oi_1_Y_C1_sg13g2_nand3_1_Y_C_sg13g2_a221oi_1_Y_A2_sg13g2_and2_1_X
+ uo_out_sg13g2_dfrbpq_1_Q_6_D_sg13g2_a21oi_1_Y_A2_sg13g2_a21o_1_X_A2_sg13g2_and2_1_X_A_sg13g2_a221oi_1_Y_C1_sg13g2_nand3_1_Y_C_sg13g2_a221oi_1_Y/A2
+ VSS VDD serial_opcode\[3\]_sg13g2_nor2_1_B/Y serial_opcode\[1\]_sg13g2_nor2_1_A/Y
+ sg13g2_and2_1
Xscan_reg\[4\]_sg13g2_dfrbpq_1_Q_D_sg13g2_a221oi_1_Y operand_a\[4\]_sg13g2_nor2b_1_A/Y
+ scan_reg\[4\]_sg13g2_dfrbpq_1_Q/D scan_reg\[5\]_sg13g2_inv_1_A/Y scan_out_sg13g2_a22oi_1_A1/B1
+ scan_out_sg13g2_a22oi_1_A1/A2 VDD scan_reg\[4\]_sg13g2_inv_1_A/Y VSS sg13g2_a221oi_1
Xserial_b\[1\]_sg13g2_dfrbpq_1_Q_D_sg13g2_o21ai_1_Y VSS VDD serial_b\[1\]_sg13g2_dfrbpq_1_Q/D
+ serial_b\[1\]_sg13g2_dfrbpq_1_Q_D_sg13g2_o21ai_1_Y/B1 ui_in[1] serial_b\[1\]_sg13g2_dfrbpq_1_Q_D_sg13g2_o21ai_1_Y/A1
+ sg13g2_o21ai_1
Xoperand_b\[1\]_sg13g2_inv_1_A operand_b\[1\]_sg13g2_inv_1_A/Y operand_b\[1\]_sg13g2_inv_1_A/A
+ VSS VDD sg13g2_inv_1
Xoperation\[3\]_sg13g2_dfrbpq_1_Q_D_sg13g2_a21oi_1_Y_A1_sg13g2_a21oi_1_A1_Y_sg13g2_nor2_1_B_Y_sg13g2_a21oi_1_B1_Y_sg13g2_nand3_1_A_Y_sg13g2_nor2_1_B_A_sg13g2_o21ai_1_Y
+ VSS VDD operation\[3\]_sg13g2_dfrbpq_1_Q_D_sg13g2_a21oi_1_Y_A1_sg13g2_a21oi_1_A1_Y_sg13g2_nor2_1_B_Y_sg13g2_a21oi_1_B1_Y_sg13g2_nand3_1_A_Y_sg13g2_nor2_1_B/A
+ operation\[3\]_sg13g2_dfrbpq_1_Q_D_sg13g2_a21oi_1_Y_A1_sg13g2_a21oi_1_A1_Y_sg13g2_nor2_1_B_Y_sg13g2_a21oi_1_B1_Y_sg13g2_nand3_1_A_Y_sg13g2_nor2_1_B_A_sg13g2_o21ai_1_Y/B1
+ overflow_flag_sg13g2_dfrbpq_1_Q_D_sg13g2_inv_1_Y_A_sg13g2_o21ai_1_Y_B1_sg13g2_nand3_1_Y_A_sg13g2_and4_1_A_B_sg13g2_or2_1_X/B
+ serial_b\[0\]_sg13g2_xnor2_1_B/A sg13g2_o21ai_1
Xscan_reg\[37\]_sg13g2_dfrbpq_1_Q_D_sg13g2_o21ai_1_Y VSS VDD scan_reg\[37\]_sg13g2_dfrbpq_1_Q/D
+ scan_reg\[38\]_sg13g2_a22oi_1_B1/Y scan_reg\[41\]_sg13g2_nor2_1_A/B scan_reg\[37\]_sg13g2_inv_1_A/Y
+ sg13g2_o21ai_1
Xmisr\[3\]_sg13g2_dfrbpq_1_Q_D_sg13g2_o21ai_1_Y_A2_sg13g2_xnor2_1_Y misr\[3\]_sg13g2_dfrbpq_1_Q_D_sg13g2_o21ai_1_Y/A2
+ misr\[3\]_sg13g2_dfrbpq_1_Q_D_sg13g2_o21ai_1_Y_A2_sg13g2_xnor2_1_Y/B VDD misr\[2\]_sg13g2_dfrbpq_1_Q/Q
+ VSS sg13g2_xnor2_1
Xscan_reg\[8\]_sg13g2_o21ai_1_A1_1 VSS VDD scan_reg\[8\]_sg13g2_o21ai_1_A1_1/Y scan_reg\[8\]_sg13g2_o21ai_1_A1_1/B1
+ scan_reg\[41\]_sg13g2_nor2_1_A/B scan_reg\[8\]_sg13g2_dfrbpq_1_Q/Q sg13g2_o21ai_1
Xmisr\[1\]_sg13g2_inv_1_A_Y_sg13g2_xnor2_1_A_B_sg13g2_o21ai_1_Y_A2_sg13g2_nand3_1_Y_B_sg13g2_nor3_1_Y
+ misr\[1\]_sg13g2_inv_1_A_Y_sg13g2_xnor2_1_A_B_sg13g2_o21ai_1_Y_A2_sg13g2_nand3_1_Y_B_sg13g2_nor3_1_Y/A
+ misr\[1\]_sg13g2_inv_1_A_Y_sg13g2_xnor2_1_A_B_sg13g2_o21ai_1_Y_A2_sg13g2_nand3_1_Y/B
+ misr\[1\]_sg13g2_inv_1_A_Y_sg13g2_xnor2_1_A_B_sg13g2_o21ai_1_Y_A2_sg13g2_nand3_1_Y_B_sg13g2_nor3_1_Y/B
+ bist_a\[7\]_sg13g2_dfrbpq_1_Q_D_sg13g2_o21ai_1_Y_A1_sg13g2_nand2_1_A_Y_sg13g2_a221oi_1_B2/C1
+ VDD VSS sg13g2_nor3_1
Xbist_pattern_count\[2\]_sg13g2_dfrbpq_1_Q VDD bist_pattern_count\[2\]_sg13g2_dfrbpq_1_Q/D
+ bist_pattern_count\[3\]_sg13g2_nand4_1_D/C clkbuf_5_3__f_clk/X VSS rst_n sg13g2_dfrbpq_1
Xscan_out_sg13g2_dfrbpq_1_Q_D_sg13g2_inv_1_Y scan_out_sg13g2_dfrbpq_1_Q/D scan_out_sg13g2_a22oi_1_A1/Y
+ VSS VDD sg13g2_inv_1
Xcarry_flag_sg13g2_dfrbpq_1_Q_D_sg13g2_inv_1_Y carry_flag_sg13g2_dfrbpq_1_Q/D carry_flag_sg13g2_o21ai_1_A1/Y
+ VSS VDD sg13g2_inv_1
Xmisr\[1\]_sg13g2_inv_1_A_Y_sg13g2_xnor2_1_A_B_sg13g2_o21ai_1_Y_A2_sg13g2_nand3_1_Y_C_sg13g2_a22oi_1_Y_B1_sg13g2_and2_1_X
+ misr\[1\]_sg13g2_inv_1_A_Y_sg13g2_xnor2_1_A_B_sg13g2_o21ai_1_Y_A2_sg13g2_nand3_1_Y_C_sg13g2_a22oi_1_Y/B1
+ VSS VDD misr\[1\]_sg13g2_inv_1_A_Y_sg13g2_xnor2_1_A_B_sg13g2_o21ai_1_Y_A2_sg13g2_nand3_1_Y_C_sg13g2_a22oi_1_Y_B1_sg13g2_and2_1_X/B
+ misr\[1\]_sg13g2_inv_1_A_Y_sg13g2_xnor2_1_A_B_sg13g2_o21ai_1_Y_A2_sg13g2_nand3_1_Y_C_sg13g2_a22oi_1_Y_B1_sg13g2_and2_1_X/A
+ sg13g2_and2_1
Xscan_reg\[11\]_sg13g2_o21ai_1_A1_1 VSS VDD scan_reg\[11\]_sg13g2_o21ai_1_A1_1/Y operand_b\[3\]_sg13g2_nand2b_1_A_N/Y
+ scan_reg\[41\]_sg13g2_nor2_1_A/B scan_reg\[11\]_sg13g2_dfrbpq_1_Q/Q sg13g2_o21ai_1
Xscan_reg\[21\]_sg13g2_dfrbpq_1_Q_D_sg13g2_a221oi_1_Y scan_reg\[21\]_sg13g2_nor2_1_A_1/Y
+ scan_reg\[21\]_sg13g2_dfrbpq_1_Q/D scan_reg\[22\]_sg13g2_inv_1_A/Y scan_out_sg13g2_a22oi_1_A1/B1
+ uo_out_sg13g2_dfrbpq_1_Q_2_D_sg13g2_o21ai_1_Y/A1 VDD ui_in[3] VSS sg13g2_a221oi_1
Xmisr\[4\]_sg13g2_dfrbpq_1_Q VDD misr\[4\]_sg13g2_dfrbpq_1_Q/D misr\[4\]_sg13g2_inv_1_A/A
+ clkbuf_5_13__f_clk/X VSS rst_n sg13g2_dfrbpq_1
Xbist_a\[7\]_sg13g2_dfrbpq_1_Q_D_sg13g2_o21ai_1_Y VSS VDD bist_a\[7\]_sg13g2_dfrbpq_1_Q/D
+ lfsr\[7\]_sg13g2_nand2_1_A/Y lfsr\[7\]_sg13g2_nand2_1_A/B bist_a\[7\]_sg13g2_dfrbpq_1_Q_D_sg13g2_o21ai_1_Y/A1
+ sg13g2_o21ai_1
Xserial_opcode\[0\]_sg13g2_dfrbpq_1_Q VDD serial_opcode\[0\]_sg13g2_dfrbpq_1_Q/D operation\[0\]_sg13g2_mux2_1_A0/A1
+ clkbuf_5_22__f_clk/X VSS rst_n sg13g2_dfrbpq_1
Xuio_out_sg13g2_nand2_1_Y_5 uio_out[6] VDD uio_out_sg13g2_nand2_1_Y_5/A VSS uio_out_sg13g2_nand2_1_Y_5/B
+ sg13g2_nand2_1
Xscan_reg\[18\]_sg13g2_dfrbpq_1_Q_D_sg13g2_a221oi_1_Y scan_reg\[19\]_sg13g2_nor2_1_A/Y
+ scan_reg\[18\]_sg13g2_dfrbpq_1_Q/D scan_out_sg13g2_a22oi_1_A1/A2 scan_reg\[18\]_sg13g2_inv_1_A/Y
+ operation\[2\]_sg13g2_inv_1_A/Y VDD ui_in[3] VSS sg13g2_a221oi_1
Xscan_reg\[14\]_sg13g2_inv_1_A scan_reg\[14\]_sg13g2_inv_1_A/Y scan_reg\[14\]_sg13g2_inv_1_A/A
+ VSS VDD sg13g2_inv_1
Xscan_reg\[3\]_sg13g2_dfrbpq_1_Q_D_sg13g2_a21oi_1_Y VDD VSS scan_out_sg13g2_a22oi_1_A1/B1
+ scan_reg\[4\]_sg13g2_inv_1_A/Y scan_reg\[3\]_sg13g2_o21ai_1_A1/Y scan_reg\[3\]_sg13g2_dfrbpq_1_Q/D
+ sg13g2_a21oi_1
Xbist_a\[7\]_sg13g2_dfrbpq_1_Q_D_sg13g2_o21ai_1_Y_A1_sg13g2_nand2_1_A_Y_sg13g2_a221oi_1_B2_Y_sg13g2_o21ai_1_B1_A2_sg13g2_nand2_1_Y_A_sg13g2_o21ai_1_Y
+ VSS VDD bist_a\[7\]_sg13g2_dfrbpq_1_Q_D_sg13g2_o21ai_1_Y_A1_sg13g2_nand2_1_A_Y_sg13g2_a221oi_1_B2_Y_sg13g2_o21ai_1_B1_A2_sg13g2_nand2_1_Y/A
+ bist_a\[7\]_sg13g2_dfrbpq_1_Q_D_sg13g2_o21ai_1_Y_A1_sg13g2_nand2_1_A_Y_sg13g2_a221oi_1_B2_Y_sg13g2_o21ai_1_B1_A1_sg13g2_nor3_1_Y/A
+ bist_a\[7\]_sg13g2_dfrbpq_1_Q_D_sg13g2_o21ai_1_Y_A1_sg13g2_nand2_1_A_Y_sg13g2_a221oi_1_B2_Y_sg13g2_o21ai_1_B1_A1_sg13g2_nor3_1_Y/C
+ bist_a\[7\]_sg13g2_dfrbpq_1_Q_D_sg13g2_o21ai_1_Y_A1_sg13g2_nand2_1_A_Y_sg13g2_a221oi_1_B2_Y_sg13g2_o21ai_1_B1_A1_sg13g2_nor3_1_Y/B
+ sg13g2_o21ai_1
Xoverflow_flag_sg13g2_dfrbpq_1_Q_D_sg13g2_inv_1_Y_A_sg13g2_o21ai_1_Y_B1_sg13g2_nand3_1_Y_C_sg13g2_a21oi_1_Y
+ VDD VSS carry_flag_sg13g2_o21ai_1_A1_B1_sg13g2_nand2_1_Y_B_sg13g2_a21oi_1_Y/A1 overflow_flag_sg13g2_dfrbpq_1_Q_D_sg13g2_inv_1_Y_A_sg13g2_o21ai_1_Y_B1_sg13g2_nand3_1_Y_C_sg13g2_a21oi_1_Y/A1
+ zero_flag_sg13g2_nand2_1_A/B overflow_flag_sg13g2_dfrbpq_1_Q_D_sg13g2_inv_1_Y_A_sg13g2_o21ai_1_Y_B1_sg13g2_nand3_1_Y/C
+ sg13g2_a21oi_1
Xscan_reg\[27\]_sg13g2_nor2_1_A scan_reg\[27\]_sg13g2_nor2_1_A/A VDD scan_reg\[27\]_sg13g2_nor2_1_A/Y
+ VSS scan_reg\[3\]_sg13g2_nor2_1_A/B sg13g2_nor2_1
Xlfsr\[3\]_sg13g2_dfrbpq_1_Q VDD lfsr\[3\]_sg13g2_dfrbpq_1_Q/D lfsr\[7\]_sg13g2_xnor2_1_B/A
+ clkbuf_5_0__f_clk/X VSS rst_n sg13g2_dfrbpq_1
Xscan_reg\[48\]_sg13g2_dfrbpq_1_Q_D_sg13g2_a221oi_1_Y_A2_sg13g2_inv_1_Y scan_reg\[48\]_sg13g2_dfrbpq_1_Q_D_sg13g2_a221oi_1_Y/A2
+ scan_out_sg13g2_a22oi_1_A1_1/B2 VSS VDD sg13g2_inv_1
Xclkbuf_4_6_0_clk clkbuf_4_6_0_clk/X VSS clkbuf_0_clk/X VDD sg13g2_buf_4
Xscan_reg\[16\]_sg13g2_dfrbpq_1_Q VDD scan_reg\[16\]_sg13g2_dfrbpq_1_Q/D scan_reg\[16\]_sg13g2_inv_1_A/A
+ clkbuf_5_29__f_clk/X VSS rst_n sg13g2_dfrbpq_1
Xscan_reg\[43\]_sg13g2_o21ai_1_A1_B1_sg13g2_nand2b_1_Y VSS fault_counter\[1\]_sg13g2_dfrbpq_1_Q/Q
+ scan_reg\[43\]_sg13g2_o21ai_1_A1/B1 ui_in[3] VDD sg13g2_nand2b_1
Xuo_out_sg13g2_dfrbpq_1_Q_2_D_sg13g2_o21ai_1_Y_A1_sg13g2_inv_1_Y uo_out_sg13g2_dfrbpq_1_Q_2_D_sg13g2_o21ai_1_Y/A1
+ uo_out[1] VSS VDD sg13g2_inv_1
Xscan_reg\[36\]_sg13g2_dfrbpq_1_Q VDD scan_reg\[36\]_sg13g2_dfrbpq_1_Q/D scan_reg\[36\]_sg13g2_inv_1_A/A
+ clkbuf_5_15__f_clk/X VSS rst_n sg13g2_dfrbpq_1
Xcarry_flag_sg13g2_o21ai_1_A1_B1_sg13g2_nand2_1_Y_B_sg13g2_a21oi_1_Y_A2_sg13g2_a21oi_1_Y_B1_sg13g2_o21ai_1_B1_Y_sg13g2_a221oi_1_B1_1_B2_sg13g2_xnor2_1_Y_B_sg13g2_o21ai_1_Y_A1_sg13g2_nand2b_1_A_N_Y_sg13g2_nand4_1_C
+ VDD uo_out_sg13g2_dfrbpq_1_Q_D_sg13g2_a21oi_1_Y_B1_sg13g2_a21oi_1_Y_A1_sg13g2_nand3_1_Y_B_sg13g2_a221oi_1_Y_B1_sg13g2_xnor2_1_Y_A_sg13g2_a21oi_1_Y_A2_sg13g2_o21ai_1_Y_A2_sg13g2_xor2_1_B_X_sg13g2_a221oi_1_A2/C1
+ carry_flag_sg13g2_o21ai_1_A1_B1_sg13g2_nand2_1_Y_B_sg13g2_a21oi_1_Y_A2_sg13g2_a21oi_1_Y_B1_sg13g2_o21ai_1_B1_Y_sg13g2_a221oi_1_B1_1_B2_sg13g2_xnor2_1_Y_B_sg13g2_o21ai_1_Y_A1_sg13g2_nand2b_1_A_N_Y_sg13g2_nand4_1_C/B
+ carry_flag_sg13g2_o21ai_1_A1_B1_sg13g2_nand2_1_Y_B_sg13g2_a21oi_1_Y_A2_sg13g2_a21oi_1_Y_B1_sg13g2_o21ai_1_B1_Y_sg13g2_a221oi_1_B1_1_B2_sg13g2_xnor2_1_Y_B_sg13g2_o21ai_1_Y_A1_sg13g2_nand2b_1_A_N/Y
+ VSS carry_flag_sg13g2_o21ai_1_A1_B1_sg13g2_nand2_1_Y_B_sg13g2_a21oi_1_Y_A2_sg13g2_a21oi_1_Y_B1_sg13g2_o21ai_1_B1_Y_sg13g2_a221oi_1_B1_1_B2_sg13g2_xnor2_1_Y_B_sg13g2_o21ai_1_Y_A1_sg13g2_nand2b_1_A_N_Y_sg13g2_nand4_1_C/A
+ carry_flag_sg13g2_o21ai_1_A1_B1_sg13g2_nand2_1_Y_B_sg13g2_a21oi_1_Y_A2_sg13g2_a21oi_1_Y_B1_sg13g2_o21ai_1_B1_Y_sg13g2_a221oi_1_B1_1_B2_sg13g2_xnor2_1_Y_B_sg13g2_o21ai_1_Y_A1_sg13g2_nand2b_1_A_N_Y_sg13g2_nand4_1_C/D
+ sg13g2_nand4_1
Xoperation\[3\]_sg13g2_dfrbpq_1_Q_D_sg13g2_a21oi_1_Y_A1_sg13g2_inv_1_Y operation\[3\]_sg13g2_dfrbpq_1_Q_D_sg13g2_a21oi_1_Y/A1
+ serial_opcode\[3\]_sg13g2_nor2_1_B/B VSS VDD sg13g2_inv_1
Xmisr\[3\]_sg13g2_dfrbpq_1_Q_D_sg13g2_o21ai_1_Y_A2_sg13g2_xnor2_1_Y_B_sg13g2_a22oi_1_Y
+ misr\[3\]_sg13g2_dfrbpq_1_Q_D_sg13g2_o21ai_1_Y_A2_sg13g2_xnor2_1_Y/B misr\[3\]_sg13g2_dfrbpq_1_Q_D_sg13g2_o21ai_1_Y_A2_sg13g2_xnor2_1_Y_B_sg13g2_a22oi_1_Y/A2
+ VDD misr\[3\]_sg13g2_dfrbpq_1_Q_D_sg13g2_o21ai_1_Y_A2_sg13g2_xnor2_1_Y_B_sg13g2_a22oi_1_Y/B1
+ uo_out_sg13g2_dfrbpq_1_Q_D_sg13g2_a21oi_1_Y_B1_sg13g2_a21oi_1_Y_A1_sg13g2_nand3_1_Y/C
+ VSS misr\[3\]_sg13g2_dfrbpq_1_Q_D_sg13g2_o21ai_1_Y_A2_sg13g2_xnor2_1_Y_B_sg13g2_a22oi_1_Y/B2
+ sg13g2_a22oi_1
Xmisr\[3\]_sg13g2_dfrbpq_1_Q_D_sg13g2_o21ai_1_Y_A2_sg13g2_xnor2_1_Y_B_sg13g2_a22oi_1_Y_B2_sg13g2_a21oi_1_Y
+ VDD VSS misr\[3\]_sg13g2_dfrbpq_1_Q_D_sg13g2_o21ai_1_Y_A2_sg13g2_xnor2_1_Y_B_sg13g2_a22oi_1_Y/A2
+ uo_out_sg13g2_dfrbpq_1_Q_5_D_sg13g2_a21oi_1_Y_A2_sg13g2_o21ai_1_Y_A2_sg13g2_mux2_1_X/A0
+ uo_out_sg13g2_dfrbpq_1_Q_D_sg13g2_a21oi_1_Y_B1_sg13g2_a21oi_1_Y_A2_sg13g2_nand3b_1_Y/A_N
+ misr\[3\]_sg13g2_dfrbpq_1_Q_D_sg13g2_o21ai_1_Y_A2_sg13g2_xnor2_1_Y_B_sg13g2_a22oi_1_Y/B2
+ sg13g2_a21oi_1
Xscan_reg\[49\]_sg13g2_dfrbpq_1_Q_D_sg13g2_a21oi_1_Y VDD VSS scan_out_sg13g2_a22oi_1_A1/B1
+ scan_reg\[50\]_sg13g2_inv_1_A/Y scan_reg\[49\]_sg13g2_o21ai_1_A1/Y scan_reg\[49\]_sg13g2_dfrbpq_1_Q/D
+ sg13g2_a21oi_1
Xscan_reg\[56\]_sg13g2_dfrbpq_1_Q VDD scan_reg\[56\]_sg13g2_dfrbpq_1_Q/D scan_reg\[56\]_sg13g2_inv_1_A/A
+ clkbuf_5_10__f_clk/X VSS rst_n sg13g2_dfrbpq_1
Xlfsr\[7\]_sg13g2_a22oi_1_A1 lfsr\[7\]_sg13g2_a22oi_1_A1/Y lfsr\[7\]_sg13g2_a22oi_1_A1/A2
+ VDD lfsr\[7\]_sg13g2_a22oi_1_A1/B1 lfsr\[7\]_sg13g2_xnor2_1_B/B VSS lfsr\[6\]_sg13g2_mux2_1_A1/A1
+ sg13g2_a22oi_1
Xnegative_flag_sg13g2_dfrbpq_1_Q_D_sg13g2_a21oi_1_Y_B1_sg13g2_nor2_1_Y uo_out[7] VDD
+ negative_flag_sg13g2_dfrbpq_1_Q_D_sg13g2_a21oi_1_Y/B1 VSS ui_in[2] sg13g2_nor2_1
Xoverflow_flag_sg13g2_dfrbpq_1_Q_D_sg13g2_inv_1_Y_A_sg13g2_o21ai_1_Y_B1_sg13g2_nand3_1_Y_A_sg13g2_and4_1_A_D_sg13g2_a221oi_1_Y_A2_sg13g2_o21ai_1_Y_B1_sg13g2_nand2_1_Y
+ overflow_flag_sg13g2_dfrbpq_1_Q_D_sg13g2_inv_1_Y_A_sg13g2_o21ai_1_Y_B1_sg13g2_nand3_1_Y_A_sg13g2_and4_1_A_D_sg13g2_a221oi_1_Y_A2_sg13g2_o21ai_1_Y/B1
+ VDD serial_opcode\[1\]_sg13g2_nor2b_1_B_N/Y VSS serial_opcode\[3\]_sg13g2_nor2_1_B/Y
+ sg13g2_nand2_1
Xmisr\[1\]_sg13g2_inv_1_A_Y_sg13g2_xnor2_1_A_B_sg13g2_o21ai_1_Y_A2_sg13g2_nand3_1_Y_A_sg13g2_nand4_1_Y_D_sg13g2_nor2b_1_Y
+ bist_a\[1\]_sg13g2_dfrbpq_1_Q/Q bist_a\[0\]_sg13g2_dfrbpq_1_Q/Q VDD bist_a\[7\]_sg13g2_dfrbpq_1_Q_D_sg13g2_o21ai_1_Y_A1_sg13g2_o21ai_1_A1_A2_sg13g2_nand3_1_Y/C
+ VSS sg13g2_nor2b_1
Xclkbuf_5_26__f_clk clkbuf_5_26__f_clk/X VSS clkbuf_4_13_0_clk/X VDD sg13g2_buf_4
Xuo_out_sg13g2_dfrbpq_1_Q_5_D_sg13g2_a21oi_1_Y_A2_sg13g2_o21ai_1_Y_B1_sg13g2_or2_1_X_B_sg13g2_nand2_1_Y_A_sg13g2_a221oi_1_Y_B2_sg13g2_xor2_1_X_A_sg13g2_nand2_1_Y
+ uo_out_sg13g2_dfrbpq_1_Q_5_D_sg13g2_a21oi_1_Y_A2_sg13g2_o21ai_1_Y_B1_sg13g2_or2_1_X_B_sg13g2_nand2_1_Y_A_sg13g2_a221oi_1_Y_B2_sg13g2_xor2_1_X/A
+ VDD uo_out_sg13g2_dfrbpq_1_Q_5_D_sg13g2_a21oi_1_Y_A2_sg13g2_o21ai_1_Y_B1_sg13g2_or2_1_X_B_sg13g2_nand2_1_Y_A_sg13g2_a221oi_1_Y_B2_sg13g2_xor2_1_X_A_sg13g2_nand2_1_Y/A
+ VSS uo_out_sg13g2_dfrbpq_1_Q_6_D_sg13g2_a21oi_1_Y_A2_sg13g2_a21o_1_X_A2_sg13g2_and2_1_X_A_sg13g2_a221oi_1_Y_B2_sg13g2_and2_1_X/A
+ sg13g2_nand2_1
Xmisr\[5\]_sg13g2_dfrbpq_1_Q_D_sg13g2_o21ai_1_Y VSS VDD misr\[5\]_sg13g2_dfrbpq_1_Q/D
+ misr\[5\]_sg13g2_dfrbpq_1_Q_D_sg13g2_o21ai_1_Y/B1 misr\[4\]_sg13g2_inv_1_A_Y_sg13g2_xnor2_1_A/Y
+ misr\[6\]_sg13g2_dfrbpq_1_Q_D_sg13g2_o21ai_1_Y/A1 sg13g2_o21ai_1
Xoverflow_flag_sg13g2_dfrbpq_1_Q_D_sg13g2_inv_1_Y_A_sg13g2_o21ai_1_Y_B1_sg13g2_nand3_1_Y_A_sg13g2_nand2_1_Y_B_sg13g2_a21oi_1_Y_A2_sg13g2_o21ai_1_Y_B1_sg13g2_and2_1_X
+ overflow_flag_sg13g2_dfrbpq_1_Q_D_sg13g2_inv_1_Y_A_sg13g2_o21ai_1_Y_B1_sg13g2_nand3_1_Y_A_sg13g2_nand2_1_Y_B_sg13g2_a21oi_1_Y_A2_sg13g2_o21ai_1_Y/B1
+ VSS VDD overflow_flag_sg13g2_dfrbpq_1_Q_D_sg13g2_inv_1_Y_A_sg13g2_o21ai_1_Y_B1_sg13g2_nand3_1_Y_A_sg13g2_nand2_1_Y_B_sg13g2_a21oi_1_Y_A2_sg13g2_o21ai_1_Y_B1_sg13g2_and2_1_X/B
+ serial_b\[6\]_sg13g2_nand2_1_A/Y sg13g2_and2_1
Xbist_a\[7\]_sg13g2_dfrbpq_1_Q_D_sg13g2_o21ai_1_Y_A1_sg13g2_o21ai_1_A1_Y_sg13g2_nand2b_1_A_N_B_sg13g2_a21oi_1_Y_A1_sg13g2_xor2_1_X
+ bist_a\[7\]_sg13g2_dfrbpq_1_Q_D_sg13g2_o21ai_1_Y_A1_sg13g2_o21ai_1_A1_Y_sg13g2_nand2b_1_A_N_B_sg13g2_a21oi_1_Y/A1
+ VDD bist_a\[4\]_sg13g2_dfrbpq_1_Q/Q bist_a\[0\]_sg13g2_dfrbpq_1_Q/Q VSS sg13g2_xor2_1
Xmisr\[1\]_sg13g2_dfrbpq_1_Q_D_sg13g2_a22oi_1_Y misr\[1\]_sg13g2_dfrbpq_1_Q/D misr\[7\]_sg13g2_dfrbpq_1_Q_D_sg13g2_a22oi_1_Y/A2
+ VDD bist_state\[3\]_sg13g2_nor2_1_A/Y misr\[1\]_sg13g2_inv_1_A/Y VSS misr\[1\]_sg13g2_dfrbpq_1_Q_D_sg13g2_a22oi_1_Y/B2
+ sg13g2_a22oi_1
Xscan_reg\[8\]_sg13g2_dfrbpq_1_Q VDD scan_reg\[8\]_sg13g2_dfrbpq_1_Q/D scan_reg\[8\]_sg13g2_dfrbpq_1_Q/Q
+ clkbuf_5_19__f_clk/X VSS rst_n sg13g2_dfrbpq_1
Xuio_out_sg13g2_nand2_1_Y_6 uio_out[5] VDD uio_out_sg13g2_nand2_1_Y_6/A VSS uio_out_sg13g2_nand2_1_Y_6/B
+ sg13g2_nand2_1
Xmisr\[0\]_sg13g2_dfrbpq_1_Q_D_sg13g2_a22oi_1_Y_B2_sg13g2_o21ai_1_Y_B1_sg13g2_a21oi_1_Y
+ VDD VSS misr\[0\]_sg13g2_dfrbpq_1_Q_D_sg13g2_a22oi_1_Y_B2_sg13g2_o21ai_1_Y/A2 misr\[7\]_sg13g2_dfrbpq_1_Q/Q
+ bist_state\[1\]_sg13g2_inv_1_A/Y misr\[0\]_sg13g2_dfrbpq_1_Q_D_sg13g2_a22oi_1_Y_B2_sg13g2_o21ai_1_Y/B1
+ sg13g2_a21oi_1
Xscan_reg\[53\]_sg13g2_dfrbpq_1_Q_D_sg13g2_a221oi_1_Y_A1_sg13g2_inv_1_Y scan_reg\[53\]_sg13g2_dfrbpq_1_Q_D_sg13g2_a221oi_1_Y/A1
+ cycle_counter\[3\]_sg13g2_dfrbpq_1_Q/Q VSS VDD sg13g2_inv_1
Xcarry_flag_sg13g2_o21ai_1_A1_B1_sg13g2_nand2_1_Y_B_sg13g2_a21oi_1_Y_A2_sg13g2_a21oi_1_Y_B1_sg13g2_o21ai_1_B1_Y_sg13g2_a221oi_1_B1
+ overflow_flag_sg13g2_dfrbpq_1_Q_D_sg13g2_inv_1_Y_A_sg13g2_o21ai_1_Y_B1_sg13g2_nand3_1_Y_C_sg13g2_a21oi_1_Y_A1_sg13g2_o21ai_1_A2/A1
+ uo_out_sg13g2_dfrbpq_1_Q_3_D_sg13g2_o21ai_1_Y_B1_sg13g2_nand2_1_Y_B_sg13g2_a22oi_1_Y_A1_sg13g2_a221oi_1_Y_C1_sg13g2_or4_1_X/A
+ serial_b\[0\]_sg13g2_xnor2_1_B/Y carry_flag_sg13g2_o21ai_1_A1_B1_sg13g2_nand2_1_Y_B_sg13g2_a21oi_1_Y_A2_sg13g2_a21oi_1_Y_B1_sg13g2_o21ai_1_B1/Y
+ carry_flag_sg13g2_o21ai_1_A1_B1_sg13g2_nand2_1_Y_B_sg13g2_a21oi_1_Y_A2_sg13g2_a21oi_1_Y/A2
+ VDD overflow_flag_sg13g2_dfrbpq_1_Q_D_sg13g2_inv_1_Y_A_sg13g2_o21ai_1_Y_B1_sg13g2_nand3_1_Y_A_sg13g2_and4_1_A_C_sg13g2_o21ai_1_Y/B1
+ VSS sg13g2_a221oi_1
Xbist_a\[7\]_sg13g2_dfrbpq_1_Q_D_sg13g2_o21ai_1_Y_A1_sg13g2_o21ai_1_A1_B1_sg13g2_nand4_1_C_Y_sg13g2_a221oi_1_C1_B1_sg13g2_nor2_1_Y_B_sg13g2_a21oi_1_Y_A2_sg13g2_nand3_1_Y
+ VDD bist_a\[7\]_sg13g2_dfrbpq_1_Q_D_sg13g2_o21ai_1_Y_A1_sg13g2_o21ai_1_A1_B1_sg13g2_nand4_1_C_Y_sg13g2_a221oi_1_C1_B1_sg13g2_nor2_1_Y_A_sg13g2_and3_1_X/C
+ bist_a\[7\]_sg13g2_dfrbpq_1_Q_D_sg13g2_o21ai_1_Y_A1_sg13g2_nand2_1_A_Y_sg13g2_a221oi_1_B2_A2_sg13g2_xnor2_1_Y_B_sg13g2_and2_1_X/A
+ misr\[1\]_sg13g2_inv_1_A_Y_sg13g2_xnor2_1_A_B_sg13g2_o21ai_1_Y_A2_sg13g2_nand3_1_Y_C_sg13g2_a22oi_1_Y_B1_sg13g2_and2_1_X/A
+ bist_a\[7\]_sg13g2_dfrbpq_1_Q_D_sg13g2_o21ai_1_Y_A1_sg13g2_nand2_1_A_Y_sg13g2_a221oi_1_B2_A2_sg13g2_xnor2_1_Y_A_sg13g2_and2_1_X/B
+ VSS sg13g2_nand3_1
Xserial_b\[6\]_sg13g2_and2_1_A serial_b\[6\]_sg13g2_and2_1_A/X VSS VDD serial_b\[6\]_sg13g2_and2_1_A/B
+ serial_b\[6\]_sg13g2_and2_1_A/A sg13g2_and2_1
Xoverflow_flag_sg13g2_dfrbpq_1_Q_D_sg13g2_inv_1_Y_A_sg13g2_o21ai_1_Y_B1_sg13g2_nand3_1_Y
+ VDD overflow_flag_sg13g2_dfrbpq_1_Q_D_sg13g2_inv_1_Y_A_sg13g2_o21ai_1_Y/B1 overflow_flag_sg13g2_dfrbpq_1_Q_D_sg13g2_inv_1_Y_A_sg13g2_o21ai_1_Y_B1_sg13g2_nand3_1_Y/B
+ overflow_flag_sg13g2_dfrbpq_1_Q_D_sg13g2_inv_1_Y_A_sg13g2_o21ai_1_Y_B1_sg13g2_nand3_1_Y/C
+ overflow_flag_sg13g2_dfrbpq_1_Q_D_sg13g2_inv_1_Y_A_sg13g2_o21ai_1_Y_B1_sg13g2_nand3_1_Y/A
+ VSS sg13g2_nand3_1
Xzero_flag_sg13g2_nand2_1_A zero_flag_sg13g2_nand2_1_A/Y VDD zero_flag_sg13g2_nand2_1_A/A
+ VSS zero_flag_sg13g2_nand2_1_A/B sg13g2_nand2_1
Xuo_out_sg13g2_dfrbpq_1_Q_1_D_sg13g2_a21oi_1_Y_A2_sg13g2_o21ai_1_Y_A2_sg13g2_o21ai_1_Y_A2_sg13g2_and2_1_X_B_sg13g2_nand2b_1_B
+ VSS uo_out_sg13g2_dfrbpq_1_Q_6_D_sg13g2_a21oi_1_Y_A2_sg13g2_a21o_1_X_A1_sg13g2_or3_1_X/C
+ uo_out_sg13g2_dfrbpq_1_Q_4_D_sg13g2_a21oi_1_Y_A2_sg13g2_a21o_1_X_B1_sg13g2_and2_1_X/A
+ uo_out_sg13g2_dfrbpq_1_Q_1_D_sg13g2_a21oi_1_Y_A2_sg13g2_o21ai_1_Y_A2_sg13g2_o21ai_1_Y_A2_sg13g2_and2_1_X/B
+ VDD sg13g2_nand2b_1
Xserial_b\[2\]_sg13g2_dfrbpq_1_Q_D_sg13g2_o21ai_1_Y VSS VDD serial_b\[2\]_sg13g2_dfrbpq_1_Q/D
+ serial_b\[2\]_sg13g2_dfrbpq_1_Q_D_sg13g2_o21ai_1_Y/B1 ui_in[1] serial_b\[2\]_sg13g2_dfrbpq_1_Q_D_sg13g2_o21ai_1_Y/A1
+ sg13g2_o21ai_1
Xbist_pattern_count\[4\]_sg13g2_and2_1_A bist_pattern_count\[4\]_sg13g2_and2_1_A/X
+ VSS VDD bist_pattern_count\[4\]_sg13g2_and2_1_A/B bist_pattern_count\[4\]_sg13g2_and2_1_A/A
+ sg13g2_and2_1
Xscan_reg\[38\]_sg13g2_dfrbpq_1_Q_D_sg13g2_o21ai_1_Y VSS VDD scan_reg\[38\]_sg13g2_dfrbpq_1_Q/D
+ scan_reg\[39\]_sg13g2_a22oi_1_B2/Y scan_reg\[41\]_sg13g2_nor2_1_A/B scan_reg\[38\]_sg13g2_inv_1_A/Y
+ sg13g2_o21ai_1
Xclkbuf_5_7__f_clk clkbuf_5_7__f_clk/X VSS clkbuf_4_3_0_clk/X VDD sg13g2_buf_4
Xuo_out_sg13g2_dfrbpq_1_Q_D_sg13g2_a21oi_1_Y_B1_sg13g2_a21oi_1_Y_A1_sg13g2_nand3_1_Y_B_sg13g2_a221oi_1_Y_B1_sg13g2_xnor2_1_Y_A_sg13g2_a21oi_1_Y_A2_sg13g2_o21ai_1_Y_A2_sg13g2_xor2_1_B_X_sg13g2_a221oi_1_A2
+ uo_out_sg13g2_dfrbpq_1_Q_D_sg13g2_a21oi_1_Y_B1_sg13g2_a21oi_1_Y_A1_sg13g2_nand3_1_Y_B_sg13g2_a221oi_1_Y_B1_sg13g2_xnor2_1_Y_A_sg13g2_a21oi_1_Y_A2_sg13g2_o21ai_1_Y_A2_sg13g2_xor2_1_B_X_sg13g2_a221oi_1_A2/C1
+ overflow_flag_sg13g2_dfrbpq_1_Q_D_sg13g2_inv_1_Y_A_sg13g2_o21ai_1_Y_B1_sg13g2_nand3_1_Y_A_sg13g2_nand2_1_Y_B_sg13g2_a21oi_1_Y_A2_sg13g2_nand3_1_C_Y_sg13g2_nand3_1_B_Y_sg13g2_nand4_1_B/C
+ carry_flag_sg13g2_o21ai_1_A1_B1_sg13g2_nand2_1_Y_B_sg13g2_a21oi_1_Y/A1 overflow_flag_sg13g2_dfrbpq_1_Q_D_sg13g2_inv_1_Y_A_sg13g2_o21ai_1_Y_B1_sg13g2_nand3_1_Y_A_sg13g2_nand2_1_Y_B_sg13g2_a21oi_1_Y_A2_sg13g2_nand3_1_C_Y_sg13g2_nand3_1_B/C
+ uo_out_sg13g2_dfrbpq_1_Q_D_sg13g2_a21oi_1_Y_B1_sg13g2_a21oi_1_Y_A1_sg13g2_nand3_1_Y_B_sg13g2_a221oi_1_Y_B1_sg13g2_xnor2_1_Y_A_sg13g2_a21oi_1_Y_A2_sg13g2_o21ai_1_Y_A2_sg13g2_xor2_1_B/X
+ VDD carry_flag_sg13g2_o21ai_1_A1_B1_sg13g2_nand2_1_Y_A_sg13g2_nand3_1_Y/C VSS sg13g2_a221oi_1
Xserial_b\[2\]_sg13g2_dfrbpq_1_Q_D_sg13g2_o21ai_1_Y_A1_sg13g2_inv_1_Y serial_b\[2\]_sg13g2_dfrbpq_1_Q_D_sg13g2_o21ai_1_Y/A1
+ serial_b\[2\]_sg13g2_xor2_1_A/A VSS VDD sg13g2_inv_1
Xscan_reg\[46\]_sg13g2_dfrbpq_1_Q_D_sg13g2_a221oi_1_Y_A2_sg13g2_inv_1_Y scan_reg\[46\]_sg13g2_dfrbpq_1_Q_D_sg13g2_a221oi_1_Y/A2
+ misr\[4\]_sg13g2_a22oi_1_B2/A1 VSS VDD sg13g2_inv_1
Xoverflow_flag_sg13g2_dfrbpq_1_Q_D_sg13g2_inv_1_Y_A_sg13g2_o21ai_1_Y_B1_sg13g2_nand3_1_Y_C_sg13g2_a21oi_1_Y_A1_sg13g2_o21ai_1_A2_B1_sg13g2_nand2_1_Y
+ overflow_flag_sg13g2_dfrbpq_1_Q_D_sg13g2_inv_1_Y_A_sg13g2_o21ai_1_Y_B1_sg13g2_nand3_1_Y_C_sg13g2_a21oi_1_Y_A1_sg13g2_o21ai_1_A2/B1
+ VDD serial_opcode\[1\]_sg13g2_nor2_1_A/Y VSS serial_opcode\[2\]_sg13g2_nor2_1_A/Y
+ sg13g2_nand2_1
Xcycle_counter\[2\]_sg13g2_dfrbpq_1_Q VDD cycle_counter\[2\]_sg13g2_dfrbpq_1_Q/D cycle_counter\[2\]_sg13g2_dfrbpq_1_Q/Q
+ clkload4/A VSS rst_n sg13g2_dfrbpq_1
Xbist_fault_sg13g2_o21ai_1_A2 VSS VDD bist_fault_sg13g2_o21ai_1_A2/Y bist_fault_sg13g2_o21ai_1_A2/B1
+ bist_fault_sg13g2_nor2_1_B/B uio_in[0] sg13g2_o21ai_1
Xbist_a\[7\]_sg13g2_dfrbpq_1_Q_D_sg13g2_o21ai_1_Y_A1_sg13g2_o21ai_1_A1_Y_sg13g2_nand2b_1_A_N
+ VSS bist_a\[7\]_sg13g2_dfrbpq_1_Q_D_sg13g2_o21ai_1_Y_A1_sg13g2_o21ai_1_A1/Y bist_a\[7\]_sg13g2_dfrbpq_1_Q_D_sg13g2_o21ai_1_Y_A1_sg13g2_o21ai_1_A1_Y_sg13g2_nand2b_1_A_N/Y
+ bist_a\[7\]_sg13g2_dfrbpq_1_Q_D_sg13g2_o21ai_1_Y_A1_sg13g2_o21ai_1_A1_Y_sg13g2_nand2b_1_A_N/B
+ VDD sg13g2_nand2b_1
Xscan_reg\[19\]_sg13g2_dfrbpq_1_Q_D_sg13g2_a21oi_1_Y VDD VSS scan_out_sg13g2_a22oi_1_A1/B1
+ scan_reg\[20\]_sg13g2_inv_1_A/Y scan_reg\[19\]_sg13g2_o21ai_1_A1/Y scan_reg\[19\]_sg13g2_dfrbpq_1_Q/D
+ sg13g2_a21oi_1
Xoverflow_flag_sg13g2_dfrbpq_1_Q_D_sg13g2_inv_1_Y_A_sg13g2_o21ai_1_Y_B1_sg13g2_nand3_1_Y_A_sg13g2_and4_1_A_D_sg13g2_a221oi_1_Y_C1_sg13g2_nor2_1_Y
+ serial_opcode\[3\]_sg13g2_nand2_1_B/Y VDD overflow_flag_sg13g2_dfrbpq_1_Q_D_sg13g2_inv_1_Y_A_sg13g2_o21ai_1_Y_B1_sg13g2_nand3_1_Y_A_sg13g2_and4_1_A_D_sg13g2_a221oi_1_Y/C1
+ VSS overflow_flag_sg13g2_dfrbpq_1_Q_D_sg13g2_inv_1_Y_A_sg13g2_o21ai_1_Y_B1_sg13g2_nand3_1_Y_A_sg13g2_and4_1_A_D_sg13g2_a221oi_1_Y_C1_sg13g2_nor2_1_Y/B
+ sg13g2_nor2_1
Xclkbuf_4_5_0_clk clkbuf_4_5_0_clk/X VSS clkbuf_0_clk/X VDD sg13g2_buf_4
Xoperand_a\[0\]_sg13g2_dfrbpq_1_Q VDD operand_a\[0\]_sg13g2_dfrbpq_1_Q/D operand_a\[0\]_sg13g2_nor2_1_A/A
+ clkbuf_5_4__f_clk/X VSS rst_n sg13g2_dfrbpq_1
Xuo_out_sg13g2_dfrbpq_1_Q_1 VDD uo_out_sg13g2_dfrbpq_1_Q_1/D uo_out[2] clkbuf_5_26__f_clk/X
+ VSS rst_n sg13g2_dfrbpq_1
Xscan_reg\[29\]_sg13g2_dfrbpq_1_Q VDD scan_reg\[29\]_sg13g2_dfrbpq_1_Q/D scan_reg\[29\]_sg13g2_inv_1_A/A
+ clkbuf_5_29__f_clk/X VSS rst_n sg13g2_dfrbpq_1
Xscan_reg\[49\]_sg13g2_dfrbpq_1_Q VDD scan_reg\[49\]_sg13g2_dfrbpq_1_Q/D scan_reg\[49\]_sg13g2_nor2_1_A/A
+ clkbuf_5_15__f_clk/X VSS rst_n sg13g2_dfrbpq_1
Xbist_done_sg13g2_dfrbpq_1_Q_D_sg13g2_o21ai_1_Y VSS VDD bist_done_sg13g2_dfrbpq_1_Q/D
+ bist_fault_sg13g2_nor2_1_B_Y_sg13g2_o21ai_1_A2/A1 bist_state\[1\]_sg13g2_a21oi_1_A1/B1
+ bist_done_sg13g2_inv_1_A/Y sg13g2_o21ai_1
Xuo_out_sg13g2_dfrbpq_1_Q_D_sg13g2_a21oi_1_Y_B1_sg13g2_a21oi_1_Y_A1_sg13g2_nand3_1_Y_B_sg13g2_a221oi_1_Y_B1_sg13g2_xnor2_1_Y_A_sg13g2_a21oi_1_Y_A2_sg13g2_o21ai_1_Y_A2_sg13g2_xor2_1_B
+ uo_out_sg13g2_dfrbpq_1_Q_D_sg13g2_a21oi_1_Y_B1_sg13g2_a21oi_1_Y_A1_sg13g2_nand3_1_Y_B_sg13g2_a221oi_1_Y_B1_sg13g2_xnor2_1_Y_A_sg13g2_a21oi_1_Y_A2_sg13g2_o21ai_1_Y_A2_sg13g2_xor2_1_B/X
+ VDD uo_out_sg13g2_dfrbpq_1_Q_D_sg13g2_a21oi_1_Y_B1_sg13g2_a21oi_1_Y_A1_sg13g2_nand3_1_Y_B_sg13g2_a221oi_1_Y_B1_sg13g2_xnor2_1_Y_A_sg13g2_a21oi_1_Y_A2_sg13g2_o21ai_1_Y/A2
+ serial_b\[1\]_sg13g2_xor2_1_A/X VSS sg13g2_xor2_1
Xmisr\[0\]_sg13g2_dfrbpq_1_Q_D_sg13g2_a22oi_1_Y_B2_sg13g2_o21ai_1_Y_A2_sg13g2_a21oi_1_Y
+ VDD VSS misr\[0\]_sg13g2_dfrbpq_1_Q_D_sg13g2_a22oi_1_Y_B2_sg13g2_o21ai_1_Y_A2_sg13g2_a21oi_1_Y/A2
+ uo_out_sg13g2_dfrbpq_1_Q_3_D_sg13g2_o21ai_1_Y_B1_sg13g2_nand2_1_Y_B_sg13g2_a22oi_1_Y/A2
+ misr\[0\]_sg13g2_dfrbpq_1_Q_D_sg13g2_a22oi_1_Y_B2_sg13g2_o21ai_1_Y_A2_sg13g2_a21oi_1_Y/B1
+ misr\[0\]_sg13g2_dfrbpq_1_Q_D_sg13g2_a22oi_1_Y_B2_sg13g2_o21ai_1_Y/A2 sg13g2_a21oi_1
Xscan_reg\[53\]_sg13g2_nor2_1_A scan_reg\[53\]_sg13g2_nor2_1_A/A VDD scan_reg\[53\]_sg13g2_nor2_1_A/Y
+ VSS scan_reg\[3\]_sg13g2_nor2_1_A/B sg13g2_nor2_1
Xnegative_flag_sg13g2_dfrbpq_1_Q_D_sg13g2_a21oi_1_Y_A2_sg13g2_o21ai_1_Y_B1_sg13g2_nand2b_1_Y
+ VSS negative_flag_sg13g2_dfrbpq_1_Q_D_sg13g2_a21oi_1_Y_A2_sg13g2_o21ai_1_Y_B1_sg13g2_nand2b_1_Y/A_N
+ negative_flag_sg13g2_dfrbpq_1_Q_D_sg13g2_a21oi_1_Y_A2_sg13g2_o21ai_1_Y/B1 misr\[7\]_sg13g2_dfrbpq_1_Q_D_sg13g2_a22oi_1_Y_B2_sg13g2_o21ai_1_Y_A2_sg13g2_a22oi_1_Y/A2
+ VDD sg13g2_nand2b_1
Xmisr\[1\]_sg13g2_inv_1_A_Y_sg13g2_xnor2_1_A_B_sg13g2_o21ai_1_Y_A2_sg13g2_nand3_1_Y
+ VDD misr\[1\]_sg13g2_inv_1_A_Y_sg13g2_xnor2_1_A_B_sg13g2_o21ai_1_Y/A2 misr\[1\]_sg13g2_inv_1_A_Y_sg13g2_xnor2_1_A_B_sg13g2_o21ai_1_Y_A2_sg13g2_nand3_1_Y/B
+ misr\[1\]_sg13g2_inv_1_A_Y_sg13g2_xnor2_1_A_B_sg13g2_o21ai_1_Y_A2_sg13g2_nand3_1_Y/C
+ misr\[1\]_sg13g2_inv_1_A_Y_sg13g2_xnor2_1_A_B_sg13g2_o21ai_1_Y_A2_sg13g2_nand3_1_Y/A
+ VSS sg13g2_nand3_1
Xuo_out_sg13g2_dfrbpq_1_Q_D_sg13g2_a21oi_1_Y_B1_sg13g2_a21oi_1_Y_A1_sg13g2_nand3_1_Y_C_sg13g2_nand4_1_Y_D_sg13g2_inv_1_Y
+ uo_out_sg13g2_dfrbpq_1_Q_D_sg13g2_a21oi_1_Y_B1_sg13g2_a21oi_1_Y_A1_sg13g2_nand3_1_Y_C_sg13g2_nand4_1_Y/D
+ uio_in[5] VSS VDD sg13g2_inv_1
Xuio_out_sg13g2_nand2_1_Y_7 uio_out[4] VDD uio_out_sg13g2_nand2_1_Y_7/A VSS uio_out_sg13g2_nand2_1_Y_7/B
+ sg13g2_nand2_1
Xnegative_flag_sg13g2_dfrbpq_1_Q VDD negative_flag_sg13g2_dfrbpq_1_Q/D uo_out[7] clkbuf_5_24__f_clk/X
+ VSS rst_n sg13g2_dfrbpq_1
Xcarry_flag_sg13g2_o21ai_1_A1_B1_sg13g2_nand2_1_Y_A_sg13g2_nand3_1_Y_A_sg13g2_a21oi_1_B1_Y_sg13g2_a22oi_1_B2
+ carry_flag_sg13g2_o21ai_1_A1_B1_sg13g2_nand2_1_Y_A_sg13g2_nand3_1_Y_A_sg13g2_a21oi_1_B1_Y_sg13g2_a22oi_1_B2/Y
+ overflow_flag_sg13g2_dfrbpq_1_Q_D_sg13g2_inv_1_Y_A_sg13g2_o21ai_1_Y_B1_sg13g2_nand3_1_Y_A_sg13g2_nand2_1_Y/B
+ VDD carry_flag_sg13g2_o21ai_1_A1_B1_sg13g2_nand2_1_Y_A_sg13g2_nand3_1_Y_A_sg13g2_a21oi_1_B1_Y_sg13g2_a22oi_1_B2/B1
+ carry_flag_sg13g2_o21ai_1_A1_B1_sg13g2_nand2_1_Y_A_sg13g2_nand3_1_Y_A_sg13g2_a21oi_1_B1_Y_sg13g2_a22oi_1_B2/A1
+ VSS carry_flag_sg13g2_o21ai_1_A1_B1_sg13g2_nand2_1_Y_A_sg13g2_nand3_1_Y_A_sg13g2_a21oi_1_B1/Y
+ sg13g2_a22oi_1
Xscan_reg\[27\]_sg13g2_dfrbpq_1_Q_D_sg13g2_o21ai_1_Y_A1_sg13g2_nor2_1_B ui_in[3] VDD
+ scan_out_sg13g2_a22oi_1_A1/B1 VSS scan_reg\[27\]_sg13g2_dfrbpq_1_Q_D_sg13g2_o21ai_1_Y/A1
+ sg13g2_nor2_1
Xuo_out_sg13g2_dfrbpq_1_Q_2_D_sg13g2_o21ai_1_Y_B1_sg13g2_nand3_1_Y_C_sg13g2_nand3_1_Y_B_sg13g2_or2_1_X_B_sg13g2_nor2_1_Y
+ uio_in[5] VDD uo_out_sg13g2_dfrbpq_1_Q_2_D_sg13g2_o21ai_1_Y_B1_sg13g2_nand3_1_Y_C_sg13g2_nand3_1_Y_B_sg13g2_or2_1_X/B
+ VSS misr\[4\]_sg13g2_inv_1_A_Y_sg13g2_xnor2_1_A_B_sg13g2_o21ai_1_Y_B1_sg13g2_or2_1_X_B_sg13g2_nor2_1_Y/B
+ sg13g2_nor2_1
Xscan_reg\[12\]_sg13g2_dfrbpq_1_Q_D_sg13g2_a221oi_1_Y scan_reg\[13\]_sg13g2_nor2_1_A/Y
+ scan_reg\[12\]_sg13g2_dfrbpq_1_Q/D scan_out_sg13g2_a22oi_1_A1/A2 scan_reg\[12\]_sg13g2_inv_1_A/Y
+ operand_b\[4\]_sg13g2_inv_1_A/Y VDD ui_in[3] VSS sg13g2_a221oi_1
Xoverflow_flag_sg13g2_dfrbpq_1_Q_D_sg13g2_inv_1_Y_A_sg13g2_o21ai_1_Y_B1_sg13g2_nand3_1_Y_A_sg13g2_and4_1_A_D_sg13g2_a221oi_1_Y_B1_sg13g2_nand3_1_Y
+ VDD overflow_flag_sg13g2_dfrbpq_1_Q_D_sg13g2_inv_1_Y_A_sg13g2_o21ai_1_Y_B1_sg13g2_nand3_1_Y_A_sg13g2_and4_1_A_D_sg13g2_a221oi_1_Y/B1
+ overflow_flag_sg13g2_dfrbpq_1_Q_D_sg13g2_inv_1_Y_A_sg13g2_o21ai_1_Y_B1_sg13g2_nand3_1_Y_A_sg13g2_and4_1_A_D_sg13g2_a221oi_1_Y_B1_sg13g2_nand3_1_Y/B
+ overflow_flag_sg13g2_dfrbpq_1_Q_D_sg13g2_inv_1_Y_A_sg13g2_o21ai_1_Y_B1_sg13g2_nand3_1_Y_A_sg13g2_and4_1_A_D_sg13g2_a221oi_1_Y_B1_sg13g2_nand3_1_Y/C
+ carry_flag_sg13g2_o21ai_1_A1_B1_sg13g2_nand2_1_Y_A_sg13g2_nand3_1_Y_B_sg13g2_nand3_1_C_Y_sg13g2_o21ai_1_B1/A1
+ VSS sg13g2_nand3_1
Xbist_a\[7\]_sg13g2_dfrbpq_1_Q_D_sg13g2_o21ai_1_Y_A1_sg13g2_o21ai_1_A1_Y_sg13g2_nand2b_1_A_N_B_sg13g2_a21oi_1_Y_A2_sg13g2_a21oi_1_Y_B1_sg13g2_nor2_1_Y
+ bist_a\[1\]_sg13g2_dfrbpq_1_Q/Q VDD bist_a\[7\]_sg13g2_dfrbpq_1_Q_D_sg13g2_o21ai_1_Y_A1_sg13g2_o21ai_1_A1_Y_sg13g2_nand2b_1_A_N_B_sg13g2_a21oi_1_Y_A2_sg13g2_a21oi_1_Y/B1
+ VSS bist_a\[7\]_sg13g2_dfrbpq_1_Q_D_sg13g2_o21ai_1_Y_A1_sg13g2_nand2_1_A_Y_sg13g2_a221oi_1_A1_A2_sg13g2_nand3_1_Y_C_sg13g2_nand3_1_Y/C
+ sg13g2_nor2_1
Xoperand_b\[2\]_sg13g2_nand2b_1_A_N VSS operand_b\[2\]_sg13g2_nor2_1_A/A scan_reg\[11\]_sg13g2_o21ai_1_A1/B1
+ ui_in[3] VDD sg13g2_nand2b_1
Xuo_out_sg13g2_dfrbpq_1_Q_5_D_sg13g2_a21oi_1_Y_A2_sg13g2_o21ai_1_Y_B1_sg13g2_or2_1_X_B_sg13g2_nand2_1_Y_B_sg13g2_a22oi_1_Y_B2_sg13g2_nor2_1_Y_A_sg13g2_a21oi_1_Y
+ VDD VSS uo_out_sg13g2_dfrbpq_1_Q_6_D_sg13g2_a21oi_1_Y_A2_sg13g2_a21o_1_X_A2_sg13g2_and2_1_X_B_sg13g2_a22oi_1_Y_B2_sg13g2_and2_1_X/A
+ serial_b\[4\]_sg13g2_nand2_1_A/Y uo_out_sg13g2_dfrbpq_1_Q_5_D_sg13g2_a21oi_1_Y_A2_sg13g2_o21ai_1_Y_B1_sg13g2_or2_1_X_B_sg13g2_nand2_1_Y_B_sg13g2_a22oi_1_Y_B1_sg13g2_nand3_1_Y/B
+ uo_out_sg13g2_dfrbpq_1_Q_5_D_sg13g2_a21oi_1_Y_A2_sg13g2_o21ai_1_Y_B1_sg13g2_or2_1_X_B_sg13g2_nand2_1_Y_B_sg13g2_a22oi_1_Y_B2_sg13g2_nor2_1_Y/A
+ sg13g2_a21oi_1
Xmisr\[4\]_sg13g2_inv_1_A_Y_sg13g2_xnor2_1_A_B_sg13g2_o21ai_1_Y_B1_sg13g2_or2_1_X_A_sg13g2_nand3_1_Y
+ VDD misr\[4\]_sg13g2_inv_1_A_Y_sg13g2_xnor2_1_A_B_sg13g2_o21ai_1_Y_B1_sg13g2_or2_1_X/A
+ misr\[4\]_sg13g2_inv_1_A_Y_sg13g2_xnor2_1_A_B_sg13g2_o21ai_1_Y_B1_sg13g2_or2_1_X_A_sg13g2_nand3_1_Y/B
+ misr\[4\]_sg13g2_inv_1_A_Y_sg13g2_xnor2_1_A_B_sg13g2_o21ai_1_Y_B1_sg13g2_or2_1_X_A_sg13g2_nand3_1_Y/C
+ misr\[4\]_sg13g2_inv_1_A_Y_sg13g2_xnor2_1_A_B_sg13g2_o21ai_1_Y_B1_sg13g2_or2_1_X_A_sg13g2_nand3_1_Y/A
+ VSS sg13g2_nand3_1
Xoperation\[1\]_sg13g2_nand2b_1_A_N VSS operation\[1\]_sg13g2_mux2_1_A0/A0 operation\[1\]_sg13g2_nand2b_1_A_N/Y
+ ui_in[3] VDD sg13g2_nand2b_1
Xoperand_b\[3\]_sg13g2_dfrbpq_1_Q VDD operand_b\[3\]_sg13g2_dfrbpq_1_Q/D operand_b\[3\]_sg13g2_nor2_1_A/A
+ clkbuf_5_18__f_clk/X VSS rst_n sg13g2_dfrbpq_1
Xserial_opcode\[2\]_sg13g2_nand2_1_A serial_opcode\[2\]_sg13g2_nand2_1_A/Y VDD serial_opcode\[2\]_sg13g2_inv_1_A/A
+ VSS serial_opcode\[3\]_sg13g2_nor2_1_B/B sg13g2_nand2_1
Xuo_out_sg13g2_dfrbpq_1_Q_5_D_sg13g2_a21oi_1_Y_A2_sg13g2_o21ai_1_Y_B1_sg13g2_or2_1_X_B_sg13g2_nand2_1_Y_A_sg13g2_a221oi_1_Y_B2_sg13g2_xor2_1_X_A_sg13g2_nand2_1_Y_A_sg13g2_nand3_1_B_A_sg13g2_and2_1_A
+ uo_out_sg13g2_dfrbpq_1_Q_5_D_sg13g2_a21oi_1_Y_A2_sg13g2_o21ai_1_Y_B1_sg13g2_or2_1_X_B_sg13g2_nand2_1_Y_B_sg13g2_a22oi_1_Y_B1_sg13g2_nand3_1_Y/B
+ VSS VDD serial_b\[5\]_sg13g2_nand2b_1_B/Y uo_out_sg13g2_dfrbpq_1_Q_5_D_sg13g2_a21oi_1_Y_A2_sg13g2_o21ai_1_Y_B1_sg13g2_or2_1_X_B_sg13g2_nand2_1_Y_A_sg13g2_a221oi_1_Y_B2_sg13g2_xor2_1_X_A_sg13g2_nand2_1_Y_A_sg13g2_nand3_1_B/A
+ sg13g2_and2_1
Xuo_out_sg13g2_dfrbpq_1_Q_3_D_sg13g2_o21ai_1_Y_B1_sg13g2_nand2_1_Y_B_sg13g2_a22oi_1_Y_A2_sg13g2_nand2_1_Y_B_sg13g2_nor3_1_Y
+ uio_in[4] uo_out_sg13g2_dfrbpq_1_Q_3_D_sg13g2_o21ai_1_Y_B1_sg13g2_nand2_1_Y_B_sg13g2_a22oi_1_Y_B2_sg13g2_mux2_1_X/A0
+ uio_in[3] uio_in[5] VDD VSS sg13g2_nor3_1
Xoperand_a\[4\]_sg13g2_nor2b_1_A operand_a\[4\]_sg13g2_nor2b_1_A/A ui_in[3] VDD operand_a\[4\]_sg13g2_nor2b_1_A/Y
+ VSS sg13g2_nor2b_1
Xoverflow_flag_sg13g2_dfrbpq_1_Q_D_sg13g2_inv_1_Y_A_sg13g2_o21ai_1_Y_B1_sg13g2_nand3_1_Y_A_sg13g2_nand2_1_Y_B_sg13g2_a21oi_1_Y_A2_sg13g2_o21ai_1_Y
+ VSS VDD overflow_flag_sg13g2_dfrbpq_1_Q_D_sg13g2_inv_1_Y_A_sg13g2_o21ai_1_Y_B1_sg13g2_nand3_1_Y_A_sg13g2_nand2_1_Y_B_sg13g2_a21oi_1_Y/A2
+ overflow_flag_sg13g2_dfrbpq_1_Q_D_sg13g2_inv_1_Y_A_sg13g2_o21ai_1_Y_B1_sg13g2_nand3_1_Y_A_sg13g2_nand2_1_Y_B_sg13g2_a21oi_1_Y_A2_sg13g2_o21ai_1_Y/B1
+ uo_out_sg13g2_dfrbpq_1_Q_5_D_sg13g2_a21oi_1_Y_A2_sg13g2_o21ai_1_Y_B1_sg13g2_or2_1_X_B_sg13g2_nand2_1_Y_B_sg13g2_a22oi_1_Y_B2_sg13g2_nor2_1_Y/A
+ overflow_flag_sg13g2_dfrbpq_1_Q_D_sg13g2_inv_1_Y_A_sg13g2_o21ai_1_Y_B1_sg13g2_nand3_1_Y_A_sg13g2_nand2_1_Y_B_sg13g2_a21oi_1_Y_A2_sg13g2_o21ai_1_Y/A1
+ sg13g2_o21ai_1
Xuo_out_sg13g2_dfrbpq_1_Q_1_D_sg13g2_a21oi_1_Y_A2_sg13g2_o21ai_1_Y VSS VDD uo_out_sg13g2_dfrbpq_1_Q_1_D_sg13g2_a21oi_1_Y/A2
+ uo_out_sg13g2_dfrbpq_1_Q_1_D_sg13g2_a21oi_1_Y_A2_sg13g2_o21ai_1_Y/B1 uo_out_sg13g2_dfrbpq_1_Q_1_D_sg13g2_a21oi_1_Y_A2_sg13g2_o21ai_1_Y/A2
+ uo_out_sg13g2_dfrbpq_1_Q_1_D_sg13g2_a21oi_1_Y_A2_sg13g2_o21ai_1_Y/A1 sg13g2_o21ai_1
Xuo_out_sg13g2_dfrbpq_1_Q_2 VDD uo_out_sg13g2_dfrbpq_1_Q_2/D uo_out[1] clkbuf_5_26__f_clk/X
+ VSS rst_n sg13g2_dfrbpq_1
Xbist_a\[7\]_sg13g2_dfrbpq_1_Q_D_sg13g2_o21ai_1_Y_A1_sg13g2_o21ai_1_A1_Y_sg13g2_nand2b_1_A_N_B_sg13g2_a21oi_1_Y
+ VDD VSS bist_a\[7\]_sg13g2_dfrbpq_1_Q_D_sg13g2_o21ai_1_Y_A1_sg13g2_o21ai_1_A1_Y_sg13g2_nand2b_1_A_N_B_sg13g2_a21oi_1_Y/A2
+ bist_a\[7\]_sg13g2_dfrbpq_1_Q_D_sg13g2_o21ai_1_Y_A1_sg13g2_o21ai_1_A1_Y_sg13g2_nand2b_1_A_N_B_sg13g2_a21oi_1_Y/A1
+ bist_a\[7\]_sg13g2_dfrbpq_1_Q_D_sg13g2_o21ai_1_Y_A1_sg13g2_o21ai_1_A1_Y_sg13g2_nand2b_1_A_N_B_sg13g2_a21oi_1_Y/B1
+ bist_a\[7\]_sg13g2_dfrbpq_1_Q_D_sg13g2_o21ai_1_Y_A1_sg13g2_o21ai_1_A1_Y_sg13g2_nand2b_1_A_N/B
+ sg13g2_a21oi_1
Xscan_reg\[44\]_sg13g2_dfrbpq_1_Q_D_sg13g2_a221oi_1_Y_A2_sg13g2_inv_1_Y scan_reg\[44\]_sg13g2_dfrbpq_1_Q_D_sg13g2_a221oi_1_Y/A2
+ fault_counter\[2\]_sg13g2_dfrbpq_1_Q/Q VSS VDD sg13g2_inv_1
Xuo_out_sg13g2_dfrbpq_1_Q_2_D_sg13g2_o21ai_1_Y_B1_sg13g2_nand3_1_Y_C_sg13g2_nand3_1_Y_C_sg13g2_a21oi_1_Y
+ VDD VSS uo_out_sg13g2_dfrbpq_1_Q_2_D_sg13g2_o21ai_1_Y_B1_sg13g2_nand3_1_Y_B_sg13g2_nand2_1_Y/A
+ uo_out_sg13g2_dfrbpq_1_Q_5_D_sg13g2_a21oi_1_Y_A2_sg13g2_o21ai_1_Y_A2_sg13g2_mux2_1_X/A0
+ negative_flag_sg13g2_dfrbpq_1_Q_D_sg13g2_a21oi_1_Y_A2_sg13g2_o21ai_1_Y/A1 uo_out_sg13g2_dfrbpq_1_Q_2_D_sg13g2_o21ai_1_Y_B1_sg13g2_nand3_1_Y_C_sg13g2_nand3_1_Y/C
+ sg13g2_a21oi_1
Xuo_out_sg13g2_dfrbpq_1_Q_D_sg13g2_a21oi_1_Y_B1_sg13g2_a21oi_1_Y_A1_sg13g2_nand3_1_Y_B_sg13g2_a221oi_1_Y_B1_sg13g2_xnor2_1_Y_B_sg13g2_xnor2_1_Y
+ uo_out_sg13g2_dfrbpq_1_Q_D_sg13g2_a21oi_1_Y_B1_sg13g2_a21oi_1_Y_A1_sg13g2_nand3_1_Y_B_sg13g2_a221oi_1_Y_B1_sg13g2_xnor2_1_Y/B
+ serial_b\[3\]_sg13g2_inv_1_A/A VDD serial_a\[3\]_sg13g2_dfrbpq_1_Q/Q VSS sg13g2_xnor2_1
Xmisr\[6\]_sg13g2_dfrbpq_1_Q_D_sg13g2_o21ai_1_Y_B1_sg13g2_nand2_1_Y misr\[6\]_sg13g2_dfrbpq_1_Q_D_sg13g2_o21ai_1_Y/B1
+ VDD misr\[6\]_sg13g2_dfrbpq_1_Q/Q VSS misr\[7\]_sg13g2_dfrbpq_1_Q_D_sg13g2_a22oi_1_Y/A2
+ sg13g2_nand2_1
Xcarry_flag_sg13g2_o21ai_1_A1_B1_sg13g2_nand2_1_Y_A_sg13g2_nand3_1_Y_A_sg13g2_a21oi_1_B1
+ VDD VSS carry_flag_sg13g2_o21ai_1_A1_B1_sg13g2_nand2_1_Y_A_sg13g2_nand3_1_Y_B_sg13g2_nand3_1_Y/C
+ serial_b\[6\]_sg13g2_nand2b_1_A_N/Y carry_flag_sg13g2_o21ai_1_A1_B1_sg13g2_nand2_1_Y_A_sg13g2_nand3_1_Y/A
+ carry_flag_sg13g2_o21ai_1_A1_B1_sg13g2_nand2_1_Y_A_sg13g2_nand3_1_Y_A_sg13g2_a21oi_1_B1/Y
+ sg13g2_a21oi_1
Xmisr\[1\]_sg13g2_inv_1_A_Y_sg13g2_xnor2_1_A_B_sg13g2_o21ai_1_Y_A2_sg13g2_nand3_1_Y_B_sg13g2_nor3_1_Y_B_sg13g2_a21oi_1_B1_A1_sg13g2_o21ai_1_Y
+ VSS VDD misr\[1\]_sg13g2_inv_1_A_Y_sg13g2_xnor2_1_A_B_sg13g2_o21ai_1_Y_A2_sg13g2_nand3_1_Y_B_sg13g2_nor3_1_Y_B_sg13g2_a21oi_1_B1/A1
+ misr\[1\]_sg13g2_inv_1_A_Y_sg13g2_xnor2_1_A_B_sg13g2_o21ai_1_Y_A2_sg13g2_nand3_1_Y_C_sg13g2_a22oi_1_Y_B1_sg13g2_and2_1_X_A_sg13g2_or3_1_X/A
+ misr\[1\]_sg13g2_inv_1_A_Y_sg13g2_xnor2_1_A_B_sg13g2_o21ai_1_Y_A2_sg13g2_nand3_1_Y_B_sg13g2_nor3_1_Y_B_sg13g2_a21oi_1_B1_A1_sg13g2_o21ai_1_Y/A2
+ misr\[1\]_sg13g2_inv_1_A_Y_sg13g2_xnor2_1_A_B_sg13g2_o21ai_1_Y_A2_sg13g2_nand3_1_Y_C_sg13g2_a22oi_1_Y_B1_sg13g2_and2_1_X_A_sg13g2_or3_1_X/B
+ sg13g2_o21ai_1
Xmisr\[6\]_sg13g2_dfrbpq_1_Q_D_sg13g2_o21ai_1_Y VSS VDD misr\[6\]_sg13g2_dfrbpq_1_Q/D
+ misr\[6\]_sg13g2_dfrbpq_1_Q_D_sg13g2_o21ai_1_Y/B1 misr\[6\]_sg13g2_dfrbpq_1_Q_D_sg13g2_o21ai_1_Y/A2
+ misr\[6\]_sg13g2_dfrbpq_1_Q_D_sg13g2_o21ai_1_Y/A1 sg13g2_o21ai_1
Xclkbuf_4_4_0_clk clkbuf_4_4_0_clk/X VSS clkbuf_0_clk/X VDD sg13g2_buf_4
Xserial_b\[2\]_sg13g2_dfrbpq_1_Q VDD serial_b\[2\]_sg13g2_dfrbpq_1_Q/D serial_b\[2\]_sg13g2_xor2_1_A/A
+ clkbuf_5_16__f_clk/X VSS rst_n sg13g2_dfrbpq_1
Xmisr\[1\]_sg13g2_inv_1_A_Y_sg13g2_xnor2_1_A_B_sg13g2_o21ai_1_Y_A2_sg13g2_nand3_1_Y_C_sg13g2_a22oi_1_Y_A2_sg13g2_xnor2_1_Y
+ misr\[1\]_sg13g2_inv_1_A_Y_sg13g2_xnor2_1_A_B_sg13g2_o21ai_1_Y_A2_sg13g2_nand3_1_Y_C_sg13g2_a22oi_1_Y/A2
+ misr\[1\]_sg13g2_inv_1_A_Y_sg13g2_xnor2_1_A_B_sg13g2_o21ai_1_Y_A2_sg13g2_nand3_1_Y_C_sg13g2_a22oi_1_Y_A2_sg13g2_xnor2_1_Y/B
+ VDD misr\[1\]_sg13g2_inv_1_A_Y_sg13g2_xnor2_1_A_B_sg13g2_o21ai_1_Y_A2_sg13g2_nand3_1_Y_C_sg13g2_a22oi_1_Y_A2_sg13g2_xnor2_1_Y/A
+ VSS sg13g2_xnor2_1
Xserial_opcode\[2\]_sg13g2_inv_1_A serial_opcode\[2\]_sg13g2_inv_1_A/Y serial_opcode\[2\]_sg13g2_inv_1_A/A
+ VSS VDD sg13g2_inv_1
Xoverflow_flag_sg13g2_dfrbpq_1_Q_D_sg13g2_inv_1_Y_A_sg13g2_o21ai_1_Y_B1_sg13g2_nand3_1_Y_A_sg13g2_and4_1_A_X_sg13g2_nand3_1_B_A_sg13g2_or2_1_X_B_sg13g2_a21oi_1_Y
+ VDD VSS carry_flag_sg13g2_o21ai_1_A1_B1_sg13g2_nand2_1_Y_B_sg13g2_a21oi_1_Y_A2_sg13g2_a21oi_1_Y/A2
+ overflow_flag_sg13g2_dfrbpq_1_Q_D_sg13g2_inv_1_Y_A_sg13g2_o21ai_1_Y_B1_sg13g2_nand3_1_Y_A_sg13g2_nand2_1_Y_B_sg13g2_a21oi_1_Y/B1
+ overflow_flag_sg13g2_dfrbpq_1_Q_D_sg13g2_inv_1_Y_A_sg13g2_o21ai_1_Y_B1_sg13g2_nand3_1_Y_A_sg13g2_and4_1_A_C_sg13g2_o21ai_1_Y/B1
+ overflow_flag_sg13g2_dfrbpq_1_Q_D_sg13g2_inv_1_Y_A_sg13g2_o21ai_1_Y_B1_sg13g2_nand3_1_Y_A_sg13g2_and4_1_A_X_sg13g2_nand3_1_B_A_sg13g2_or2_1_X/B
+ sg13g2_a21oi_1
Xbist_a\[7\]_sg13g2_dfrbpq_1_Q_D_sg13g2_o21ai_1_Y_A1_sg13g2_nand2_1_A_Y_sg13g2_a221oi_1_B2_B1_sg13g2_nand2_1_Y
+ bist_a\[7\]_sg13g2_dfrbpq_1_Q_D_sg13g2_o21ai_1_Y_A1_sg13g2_nand2_1_A_Y_sg13g2_a221oi_1_B2/B1
+ VDD bist_a\[7\]_sg13g2_dfrbpq_1_Q_D_sg13g2_o21ai_1_Y_A1_sg13g2_nand2_1_A_Y_sg13g2_a221oi_1_B2_B1_sg13g2_nand2_1_Y/A
+ VSS bist_a\[7\]_sg13g2_dfrbpq_1_Q_D_sg13g2_o21ai_1_Y_A1_sg13g2_nand2_1_A_Y_sg13g2_a221oi_1_B2_B1_sg13g2_nand2_1_Y/B
+ sg13g2_nand2_1
Xbist_state\[1\]_sg13g2_inv_1_A bist_state\[1\]_sg13g2_inv_1_A/Y bist_state\[1\]_sg13g2_inv_1_A/A
+ VSS VDD sg13g2_inv_1
Xcarry_flag_sg13g2_o21ai_1_A1_B1_sg13g2_nand2_1_Y_B_sg13g2_a21oi_1_Y_A2_sg13g2_a21oi_1_Y_B1_sg13g2_o21ai_1_B1
+ VSS VDD carry_flag_sg13g2_o21ai_1_A1_B1_sg13g2_nand2_1_Y_B_sg13g2_a21oi_1_Y_A2_sg13g2_a21oi_1_Y_B1_sg13g2_o21ai_1_B1/Y
+ carry_flag_sg13g2_o21ai_1_A1_B1_sg13g2_nand2_1_Y_B_sg13g2_a21oi_1_Y_A2_sg13g2_a21oi_1_Y/B1
+ carry_flag_sg13g2_o21ai_1_A1_B1_sg13g2_nand2_1_Y_B_sg13g2_a21oi_1_Y_A2_sg13g2_a21oi_1_Y_B1_sg13g2_o21ai_1_B1/A2
+ serial_b\[6\]_sg13g2_and2_1_A/X sg13g2_o21ai_1
Xbist_pattern_count\[4\]_sg13g2_dfrbpq_1_Q_D_sg13g2_nor3_1_Y bist_pattern_count\[4\]_sg13g2_and2_1_A/X
+ bist_pattern_count\[4\]_sg13g2_dfrbpq_1_Q/D bist_fault_sg13g2_dfrbpq_1_Q_D_sg13g2_nor3_1_Y/A
+ bist_pattern_count\[4\]_sg13g2_dfrbpq_1_Q_D_sg13g2_nor3_1_Y/C VDD VSS sg13g2_nor3_1
Xbist_fault_sg13g2_nor2_1_B_Y_sg13g2_o21ai_1_A2_B1_sg13g2_nand3b_1_Y_B_sg13g2_nand2_1_B_Y_sg13g2_nand3_1_C
+ VDD misr\[6\]_sg13g2_dfrbpq_1_Q_D_sg13g2_o21ai_1_Y/A1 bist_fault_sg13g2_o21ai_1_A2/Y
+ bist_fault_sg13g2_nor2_1_B_Y_sg13g2_o21ai_1_A2_B1_sg13g2_nand3b_1_Y_B_sg13g2_nand2_1_B/Y
+ bist_state\[1\]_sg13g2_inv_1_A/A VSS sg13g2_nand3_1
Xscan_reg\[6\]_sg13g2_o21ai_1_A1 VSS VDD scan_reg\[6\]_sg13g2_o21ai_1_A1/Y scan_reg\[6\]_sg13g2_o21ai_1_A1/B1
+ scan_reg\[3\]_sg13g2_nor2_1_A/B scan_reg\[6\]_sg13g2_dfrbpq_1_Q/Q sg13g2_o21ai_1
Xserial_b\[3\]_sg13g2_dfrbpq_1_Q_D_sg13g2_o21ai_1_Y VSS VDD serial_b\[3\]_sg13g2_dfrbpq_1_Q/D
+ serial_b\[3\]_sg13g2_dfrbpq_1_Q_D_sg13g2_o21ai_1_Y/B1 ui_in[1] serial_b\[3\]_sg13g2_inv_1_A/Y
+ sg13g2_o21ai_1
Xuo_out_sg13g2_dfrbpq_1_Q_2_D_sg13g2_o21ai_1_Y_B1_sg13g2_nand3_1_Y_C_sg13g2_nand3_1_Y_A_sg13g2_nand2b_1_Y
+ VSS uo_out_sg13g2_dfrbpq_1_Q_3_D_sg13g2_o21ai_1_Y_B1_sg13g2_nand2_1_Y_B_sg13g2_a22oi_1_Y/A1
+ uo_out_sg13g2_dfrbpq_1_Q_2_D_sg13g2_o21ai_1_Y_B1_sg13g2_nand3_1_Y_C_sg13g2_nand3_1_Y/A
+ uio_in[1] VDD sg13g2_nand2b_1
Xscan_reg\[39\]_sg13g2_dfrbpq_1_Q_D_sg13g2_o21ai_1_Y VSS VDD scan_reg\[39\]_sg13g2_dfrbpq_1_Q/D
+ scan_reg\[40\]_sg13g2_a22oi_1_B1/Y scan_reg\[41\]_sg13g2_nor2_1_A/B scan_reg\[39\]_sg13g2_inv_1_A/Y
+ sg13g2_o21ai_1
Xmisr\[1\]_sg13g2_inv_1_A_Y_sg13g2_xnor2_1_A_B_sg13g2_o21ai_1_Y_A2_sg13g2_nand3_1_Y_C_sg13g2_a22oi_1_Y_A2_sg13g2_xnor2_1_Y_B_sg13g2_a21oi_1_Y_A1_sg13g2_xnor2_1_Y
+ misr\[1\]_sg13g2_inv_1_A_Y_sg13g2_xnor2_1_A_B_sg13g2_o21ai_1_Y_A2_sg13g2_nand3_1_Y_C_sg13g2_a22oi_1_Y_A2_sg13g2_xnor2_1_Y_B_sg13g2_a21oi_1_Y/A1
+ bist_a\[5\]_sg13g2_dfrbpq_1_Q/Q VDD bist_a\[1\]_sg13g2_dfrbpq_1_Q/Q VSS sg13g2_xnor2_1
Xclkbuf_5_15__f_clk clkbuf_5_15__f_clk/X VSS clkbuf_4_7_0_clk/X VDD sg13g2_buf_4
Xscan_reg\[35\]_sg13g2_a22oi_1_B1 scan_reg\[35\]_sg13g2_a22oi_1_B1/Y ui_in[3] VDD
+ scan_reg\[35\]_sg13g2_inv_1_A/A misr\[2\]_sg13g2_dfrbpq_1_Q/Q VSS scan_out_sg13g2_a22oi_1_A1/B1
+ sg13g2_a22oi_1
Xoperand_b\[7\]_sg13g2_nand2b_1_A_N VSS operand_b\[7\]_sg13g2_mux2_1_A0/A0 operand_b\[7\]_sg13g2_nand2b_1_A_N/Y
+ ui_in[3] VDD sg13g2_nand2b_1
Xoperand_b\[1\]_sg13g2_dfrbpq_1_Q_D_sg13g2_o21ai_1_Y VSS VDD operand_b\[1\]_sg13g2_dfrbpq_1_Q/D
+ operand_b\[1\]_sg13g2_dfrbpq_1_Q_D_sg13g2_o21ai_1_Y/B1 ui_in[2] operand_b\[1\]_sg13g2_inv_1_A/Y
+ sg13g2_o21ai_1
Xuo_out_sg13g2_dfrbpq_1_Q_3 VDD uo_out_sg13g2_dfrbpq_1_Q_3/D uo_out[0] clkbuf_5_26__f_clk/X
+ VSS rst_n sg13g2_dfrbpq_1
Xmisr\[7\]_sg13g2_dfrbpq_1_Q_D_sg13g2_a22oi_1_Y_B2_sg13g2_o21ai_1_Y_A2_sg13g2_a22oi_1_Y_B2_sg13g2_a21oi_1_Y_A2_sg13g2_inv_1_Y
+ misr\[7\]_sg13g2_dfrbpq_1_Q_D_sg13g2_a22oi_1_Y_B2_sg13g2_o21ai_1_Y_A2_sg13g2_a22oi_1_Y_B2_sg13g2_a21oi_1_Y/A2
+ misr\[6\]_sg13g2_dfrbpq_1_Q_D_sg13g2_o21ai_1_Y_A2_sg13g2_xnor2_1_Y_B_sg13g2_a22oi_1_Y/A1
+ VSS VDD sg13g2_inv_1
Xbist_pattern_count\[6\]_sg13g2_nand3_1_C_Y_sg13g2_nor3_1_C bist_pattern_count\[6\]_sg13g2_nand3_1_C_Y_sg13g2_nor3_1_C/A
+ bist_pattern_count\[6\]_sg13g2_nand3_1_C_Y_sg13g2_nor3_1_C/Y bist_pattern_count\[3\]_sg13g2_nand4_1_D/Y
+ bist_pattern_count\[6\]_sg13g2_nand3_1_C/Y VDD VSS sg13g2_nor3_1
Xmisr\[6\]_sg13g2_dfrbpq_1_Q_D_sg13g2_o21ai_1_Y_A2_sg13g2_xnor2_1_Y_B_sg13g2_a22oi_1_Y_A1_sg13g2_and4_1_X_B_sg13g2_nand4_1_Y
+ VDD misr\[6\]_sg13g2_dfrbpq_1_Q_D_sg13g2_o21ai_1_Y_A2_sg13g2_xnor2_1_Y_B_sg13g2_a22oi_1_Y_A1_sg13g2_and4_1_X/B
+ lfsr\[6\]_sg13g2_mux2_1_A1/A0 bist_a\[7\]_sg13g2_or2_1_A/B VSS bist_a\[2\]_sg13g2_dfrbpq_1_Q/Q
+ bist_a\[7\]_sg13g2_dfrbpq_1_Q_D_sg13g2_o21ai_1_Y_A1_sg13g2_o21ai_1_A1_B1_sg13g2_a21oi_1_Y_A2_sg13g2_and2_1_X/B
+ sg13g2_nand4_1
Xoperation\[1\]_sg13g2_dfrbpq_1_Q VDD operation\[1\]_sg13g2_mux2_1_A0/X operation\[1\]_sg13g2_mux2_1_A0/A0
+ clkbuf_5_28__f_clk/X VSS rst_n sg13g2_dfrbpq_1
Xuo_out_sg13g2_dfrbpq_1_Q_D_sg13g2_a21oi_1_Y VDD VSS zero_flag_sg13g2_nand2_1_A/B
+ uo_out_sg13g2_dfrbpq_1_Q_D_sg13g2_a21oi_1_Y/A1 uo_out_sg13g2_dfrbpq_1_Q_D_sg13g2_a21oi_1_Y/B1
+ uo_out_sg13g2_dfrbpq_1_Q/D sg13g2_a21oi_1
Xserial_a\[6\]_sg13g2_dfrbpq_1_Q_D_sg13g2_mux2_1_X serial_a\[7\]_sg13g2_dfrbpq_1_Q/Q
+ serial_a\[6\]_sg13g2_dfrbpq_1_Q/D ui_in[1] VDD VSS serial_b\[6\]_sg13g2_and2_1_A/B
+ sg13g2_mux2_1
Xscan_reg\[53\]_sg13g2_dfrbpq_1_Q_D_sg13g2_a221oi_1_Y scan_reg\[53\]_sg13g2_nor2_1_A_1/Y
+ scan_reg\[53\]_sg13g2_dfrbpq_1_Q/D scan_out_sg13g2_a22oi_1_A1/B1 scan_reg\[54\]_sg13g2_inv_1_A/Y
+ ui_in[3] VDD scan_reg\[53\]_sg13g2_dfrbpq_1_Q_D_sg13g2_a221oi_1_Y/A1 VSS sg13g2_a221oi_1
Xoverflow_flag_sg13g2_dfrbpq_1_Q_D_sg13g2_inv_1_Y_A_sg13g2_o21ai_1_Y_B1_sg13g2_nand3_1_Y_A_sg13g2_nand2_1_Y_B_sg13g2_a21oi_1_Y_A2_sg13g2_nand3_1_C_Y_sg13g2_nand3_1_B_Y_sg13g2_nand4_1_B
+ VDD overflow_flag_sg13g2_dfrbpq_1_Q_D_sg13g2_inv_1_Y_A_sg13g2_o21ai_1_Y_B1_sg13g2_nand3_1_Y_A_sg13g2_nand2_1_Y_B_sg13g2_a21oi_1_Y_A2_sg13g2_nand3_1_C_Y_sg13g2_nand3_1_B_Y_sg13g2_nand4_1_B/Y
+ overflow_flag_sg13g2_dfrbpq_1_Q_D_sg13g2_inv_1_Y_A_sg13g2_o21ai_1_Y_B1_sg13g2_nand3_1_Y_A_sg13g2_nand2_1_Y_B_sg13g2_a21oi_1_Y_A2_sg13g2_nand3_1_C_Y_sg13g2_nand3_1_B/Y
+ overflow_flag_sg13g2_dfrbpq_1_Q_D_sg13g2_inv_1_Y_A_sg13g2_o21ai_1_Y_B1_sg13g2_nand3_1_Y_A_sg13g2_nand2_1_Y_B_sg13g2_a21oi_1_Y_A2_sg13g2_nand3_1_C_Y_sg13g2_nand3_1_B_Y_sg13g2_nand4_1_B/C
+ VSS carry_flag_sg13g2_o21ai_1_A1_B1_sg13g2_nand2_1_Y_A_sg13g2_nand3_1_Y_A_sg13g2_a21oi_1_B1_Y_sg13g2_a22oi_1_B2/Y
+ overflow_flag_sg13g2_dfrbpq_1_Q_D_sg13g2_inv_1_Y_A_sg13g2_o21ai_1_Y_B1_sg13g2_nand3_1_Y_A_sg13g2_nand2_1_Y_B_sg13g2_a21oi_1_Y_A2_sg13g2_nand3_1_C_Y_sg13g2_nand3_1_B_Y_sg13g2_nand4_1_B/D
+ sg13g2_nand4_1
Xmisr\[7\]_sg13g2_dfrbpq_1_Q_D_sg13g2_a22oi_1_Y_A1_sg13g2_inv_1_Y misr\[7\]_sg13g2_dfrbpq_1_Q_D_sg13g2_a22oi_1_Y/A1
+ misr\[7\]_sg13g2_dfrbpq_1_Q/Q VSS VDD sg13g2_inv_1
Xserial_opcode\[1\]_sg13g2_dfrbpq_1_Q_D_sg13g2_a21oi_1_Y_B1_sg13g2_nor2_1_Y operation\[1\]_sg13g2_mux2_1_A0/A1
+ VDD serial_opcode\[1\]_sg13g2_dfrbpq_1_Q_D_sg13g2_a21oi_1_Y/B1 VSS ui_in[1] sg13g2_nor2_1
Xuo_out_sg13g2_dfrbpq_1_Q_D_sg13g2_a21oi_1_Y_B1_sg13g2_a21oi_1_Y_A1_sg13g2_nand3_1_Y_B_sg13g2_a221oi_1_Y_B1_sg13g2_xnor2_1_Y_A_sg13g2_a21oi_1_Y
+ VDD VSS uo_out_sg13g2_dfrbpq_1_Q_D_sg13g2_a21oi_1_Y_B1_sg13g2_a21oi_1_Y_A1_sg13g2_nand3_1_Y_B_sg13g2_a221oi_1_Y_B1_sg13g2_xnor2_1_Y_A_sg13g2_a21oi_1_Y/A2
+ uo_out_sg13g2_dfrbpq_1_Q_D_sg13g2_a21oi_1_Y_B1_sg13g2_a21oi_1_Y_A1_sg13g2_nand3_1_Y_B_sg13g2_a221oi_1_Y_B1_sg13g2_xnor2_1_Y_A_sg13g2_a21oi_1_Y/A1
+ uo_out_sg13g2_dfrbpq_1_Q_D_sg13g2_a21oi_1_Y_B1_sg13g2_a21oi_1_Y_A1_sg13g2_nand3_1_Y_B_sg13g2_a221oi_1_Y_B1_sg13g2_xnor2_1_Y_A_sg13g2_a21oi_1_Y/B1
+ uo_out_sg13g2_dfrbpq_1_Q_D_sg13g2_a21oi_1_Y_B1_sg13g2_a21oi_1_Y_A1_sg13g2_nand3_1_Y_B_sg13g2_a221oi_1_Y_B1_sg13g2_xnor2_1_Y/A
+ sg13g2_a21oi_1
Xoverflow_flag_sg13g2_dfrbpq_1_Q_D_sg13g2_inv_1_Y overflow_flag_sg13g2_dfrbpq_1_Q/D
+ overflow_flag_sg13g2_dfrbpq_1_Q_D_sg13g2_inv_1_Y/A VSS VDD sg13g2_inv_1
Xmisr\[4\]_sg13g2_inv_1_A_Y_sg13g2_xnor2_1_A misr\[4\]_sg13g2_inv_1_A_Y_sg13g2_xnor2_1_A/Y
+ misr\[4\]_sg13g2_inv_1_A_Y_sg13g2_xnor2_1_A/B VDD misr\[4\]_sg13g2_inv_1_A/Y VSS
+ sg13g2_xnor2_1
Xscan_reg\[11\]_sg13g2_dfrbpq_1_Q VDD scan_reg\[11\]_sg13g2_dfrbpq_1_Q/D scan_reg\[11\]_sg13g2_dfrbpq_1_Q/Q
+ clkbuf_5_19__f_clk/X VSS rst_n sg13g2_dfrbpq_1
Xscan_reg\[5\]_sg13g2_dfrbpq_1_Q_D_sg13g2_a21oi_1_Y VDD VSS scan_out_sg13g2_a22oi_1_A1/A2
+ scan_reg\[5\]_sg13g2_inv_1_A/Y scan_reg\[6\]_sg13g2_o21ai_1_A1/Y scan_reg\[5\]_sg13g2_dfrbpq_1_Q/D
+ sg13g2_a21oi_1
Xzero_flag_sg13g2_dfrbpq_1_Q_D_sg13g2_o21ai_1_Y VSS VDD zero_flag_sg13g2_dfrbpq_1_Q/D
+ zero_flag_sg13g2_nand2_1_A/Y zero_flag_sg13g2_dfrbpq_1_Q_D_sg13g2_o21ai_1_Y/A2 zero_flag_sg13g2_dfrbpq_1_Q_D_sg13g2_o21ai_1_Y/A1
+ sg13g2_o21ai_1
Xclkbuf_4_3_0_clk clkbuf_4_3_0_clk/X VSS clkbuf_0_clk/X VDD sg13g2_buf_4
Xscan_reg\[31\]_sg13g2_dfrbpq_1_Q VDD scan_reg\[31\]_sg13g2_dfrbpq_1_Q/D scan_reg\[31\]_sg13g2_inv_1_A/A
+ clkbuf_5_19__f_clk/X VSS rst_n sg13g2_dfrbpq_1
Xbist_a\[0\]_sg13g2_dfrbpq_1_Q_D_sg13g2_a21oi_1_Y_B1_sg13g2_nor2_1_Y bist_a\[0\]_sg13g2_dfrbpq_1_Q/Q
+ VDD bist_a\[0\]_sg13g2_dfrbpq_1_Q_D_sg13g2_a21oi_1_Y/B1 VSS lfsr\[7\]_sg13g2_nand2_1_A/B
+ sg13g2_nor2_1
Xcarry_flag_sg13g2_o21ai_1_A1_B1_sg13g2_nand2_1_Y_A_sg13g2_nand3_1_Y_A_sg13g2_a21oi_1_B1_Y_sg13g2_a22oi_1_B2_B1_sg13g2_nor2_1_Y
+ serial_opcode\[2\]_sg13g2_nand2_1_A/Y VDD carry_flag_sg13g2_o21ai_1_A1_B1_sg13g2_nand2_1_Y_A_sg13g2_nand3_1_Y_A_sg13g2_a21oi_1_B1_Y_sg13g2_a22oi_1_B2/B1
+ VSS serial_opcode\[2\]_sg13g2_nor3_1_A/C sg13g2_nor2_1
Xcarry_flag_sg13g2_o21ai_1_A1_B1_sg13g2_nand2_1_Y_B_sg13g2_a21oi_1_Y_A2_sg13g2_a21oi_1_Y_A1_sg13g2_nand2_1_Y
+ carry_flag_sg13g2_o21ai_1_A1_B1_sg13g2_nand2_1_Y_B_sg13g2_a21oi_1_Y_A2_sg13g2_a21oi_1_Y/A1
+ VDD serial_a\[7\]_sg13g2_dfrbpq_1_Q/Q VSS serial_b\[7\]_sg13g2_dfrbpq_1_Q/Q sg13g2_nand2_1
Xscan_reg\[51\]_sg13g2_dfrbpq_1_Q VDD scan_reg\[51\]_sg13g2_dfrbpq_1_Q/D scan_reg\[51\]_sg13g2_nor2_1_A/A
+ clkload4/A VSS rst_n sg13g2_dfrbpq_1
Xscan_reg\[47\]_sg13g2_o21ai_1_A1 VSS VDD scan_reg\[47\]_sg13g2_o21ai_1_A1/Y scan_reg\[47\]_sg13g2_o21ai_1_A1/B1
+ scan_reg\[41\]_sg13g2_nor2_1_A/B scan_reg\[47\]_sg13g2_nor2_1_A/A sg13g2_o21ai_1
Xoverflow_flag_sg13g2_dfrbpq_1_Q_D_sg13g2_inv_1_Y_A_sg13g2_o21ai_1_Y_B1_sg13g2_nand3_1_Y_C_sg13g2_a21oi_1_Y_A1_sg13g2_o21ai_1_A2
+ VSS VDD uo_out_sg13g2_dfrbpq_1_Q_6_D_sg13g2_a21oi_1_Y_A2_sg13g2_a21o_1_X_A2_sg13g2_and2_1_X_B_sg13g2_a22oi_1_Y/B1
+ overflow_flag_sg13g2_dfrbpq_1_Q_D_sg13g2_inv_1_Y_A_sg13g2_o21ai_1_Y_B1_sg13g2_nand3_1_Y_C_sg13g2_a21oi_1_Y_A1_sg13g2_o21ai_1_A2/B1
+ overflow_flag_sg13g2_dfrbpq_1_Q_D_sg13g2_inv_1_Y_A_sg13g2_o21ai_1_Y_B1_sg13g2_nand3_1_Y_C_sg13g2_a21oi_1_Y/A1
+ overflow_flag_sg13g2_dfrbpq_1_Q_D_sg13g2_inv_1_Y_A_sg13g2_o21ai_1_Y_B1_sg13g2_nand3_1_Y_C_sg13g2_a21oi_1_Y_A1_sg13g2_o21ai_1_A2/A1
+ sg13g2_o21ai_1
Xlfsr\[2\]_sg13g2_a22oi_1_A1 lfsr\[2\]_sg13g2_a22oi_1_A1/Y lfsr\[7\]_sg13g2_a22oi_1_A1/A2
+ VDD lfsr\[7\]_sg13g2_a22oi_1_A1/B1 lfsr\[2\]_sg13g2_nand2_1_A/A VSS lfsr\[1\]_sg13g2_nand2_1_A/A
+ sg13g2_a22oi_1
Xlfsr\[2\]_sg13g2_a22oi_1_B2 lfsr\[2\]_sg13g2_a22oi_1_B2/Y lfsr\[7\]_sg13g2_a22oi_1_A1/A2
+ VDD lfsr\[7\]_sg13g2_a22oi_1_A1/B1 lfsr\[7\]_sg13g2_xnor2_1_B/A VSS lfsr\[2\]_sg13g2_nand2_1_A/A
+ sg13g2_a22oi_1
Xoperand_a\[6\]_sg13g2_dfrbpq_1_Q VDD operand_a\[6\]_sg13g2_mux2_1_A0/X operand_a\[6\]_sg13g2_mux2_1_A0/A0
+ clkbuf_5_20__f_clk/X VSS rst_n sg13g2_dfrbpq_1
Xmisr\[1\]_sg13g2_dfrbpq_1_Q_D_sg13g2_a22oi_1_Y_B2_sg13g2_o21ai_1_Y_A2_sg13g2_a22oi_1_Y_B1_sg13g2_or2_1_X
+ negative_flag_sg13g2_dfrbpq_1_Q_D_sg13g2_a21oi_1_Y_A2_sg13g2_o21ai_1_Y_A2_sg13g2_o21ai_1_Y/A1
+ VSS misr\[0\]_sg13g2_dfrbpq_1_Q_D_sg13g2_a22oi_1_Y_B2_sg13g2_o21ai_1_Y_A2_sg13g2_a21oi_1_Y/A2
+ misr\[1\]_sg13g2_dfrbpq_1_Q_D_sg13g2_a22oi_1_Y_B2_sg13g2_o21ai_1_Y_A2_sg13g2_a22oi_1_Y/B1
+ VDD sg13g2_or2_1
Xbist_a\[7\]_sg13g2_dfrbpq_1_Q_D_sg13g2_o21ai_1_Y_A1_sg13g2_nand2_1_A_Y_sg13g2_a221oi_1_A1_A2_sg13g2_nand3_1_Y
+ VDD bist_a\[7\]_sg13g2_dfrbpq_1_Q_D_sg13g2_o21ai_1_Y_A1_sg13g2_nand2_1_A_Y_sg13g2_a221oi_1_A1/A2
+ bist_a\[7\]_sg13g2_dfrbpq_1_Q_D_sg13g2_o21ai_1_Y_A1_sg13g2_nand2_1_A_Y_sg13g2_a221oi_1_A1_A2_sg13g2_nand3_1_Y/B
+ bist_a\[7\]_sg13g2_dfrbpq_1_Q_D_sg13g2_o21ai_1_Y_A1_sg13g2_nand2_1_A_Y_sg13g2_a221oi_1_A1_A2_sg13g2_nand3_1_Y/C
+ bist_a\[7\]_sg13g2_or2_1_A/A VSS sg13g2_nand3_1
Xoperand_b\[4\]_sg13g2_dfrbpq_1_Q_D_sg13g2_o21ai_1_Y_B1_sg13g2_nand2_1_Y operand_b\[4\]_sg13g2_dfrbpq_1_Q_D_sg13g2_o21ai_1_Y/B1
+ VDD serial_b\[4\]_sg13g2_nand2_1_A/A VSS ui_in[2] sg13g2_nand2_1
Xuo_out_sg13g2_dfrbpq_1_Q_5_D_sg13g2_a21oi_1_Y_A2_sg13g2_o21ai_1_Y_B1_sg13g2_or2_1_X_B_sg13g2_nand2_1_Y_A_sg13g2_a221oi_1_Y_C1_sg13g2_nand4_1_Y
+ VDD uo_out_sg13g2_dfrbpq_1_Q_5_D_sg13g2_a21oi_1_Y_A2_sg13g2_o21ai_1_Y_B1_sg13g2_or2_1_X_B_sg13g2_nand2_1_Y_A_sg13g2_a221oi_1_Y/C1
+ uo_out_sg13g2_dfrbpq_1_Q_5_D_sg13g2_a21oi_1_Y_A2_sg13g2_o21ai_1_Y_B1_sg13g2_or2_1_X_B_sg13g2_nand2_1_Y_A_sg13g2_a221oi_1_Y_C1_sg13g2_nand4_1_Y/B
+ uo_out_sg13g2_dfrbpq_1_Q_5_D_sg13g2_a21oi_1_Y_A2_sg13g2_o21ai_1_Y_B1_sg13g2_or2_1_X_B_sg13g2_nand2_1_Y_A_sg13g2_a221oi_1_Y_C1_sg13g2_nand4_1_Y/C
+ VSS carry_flag_sg13g2_o21ai_1_A1_B1_sg13g2_nand2_1_Y_A_sg13g2_nand3_1_Y_A_sg13g2_a21oi_1_B1_Y_sg13g2_a22oi_1_B2/Y
+ uo_out_sg13g2_dfrbpq_1_Q_5_D_sg13g2_a21oi_1_Y_A2_sg13g2_o21ai_1_Y_B1_sg13g2_or2_1_X_B_sg13g2_nand2_1_Y_A_sg13g2_a221oi_1_Y_C1_sg13g2_nand4_1_Y/D
+ sg13g2_nand4_1
Xoperation\[3\]_sg13g2_nor2_1_A operation\[3\]_sg13g2_nor2_1_A/A VDD operation\[3\]_sg13g2_nor2_1_A/Y
+ VSS ui_in[2] sg13g2_nor2_1
Xoverflow_flag_sg13g2_dfrbpq_1_Q_D_sg13g2_inv_1_Y_A_sg13g2_o21ai_1_Y_B1_sg13g2_nand3_1_Y_A_sg13g2_nand2_1_Y_B_sg13g2_a21oi_1_Y_A2_sg13g2_o21ai_1_Y_B1_sg13g2_a22oi_1_B2_Y_sg13g2_nand4_1_C_Y_sg13g2_a221oi_1_C1_B2_sg13g2_nor2_1_Y
+ carry_flag_sg13g2_o21ai_1_A1_B1_sg13g2_nand2_1_Y_A_sg13g2_nand3_1_Y_B_sg13g2_nand3_1_Y_A_sg13g2_nor3_1_A/C
+ VDD overflow_flag_sg13g2_dfrbpq_1_Q_D_sg13g2_inv_1_Y_A_sg13g2_o21ai_1_Y_B1_sg13g2_nand3_1_Y_A_sg13g2_nand2_1_Y_B_sg13g2_a21oi_1_Y_A2_sg13g2_o21ai_1_Y_B1_sg13g2_a22oi_1_B2_Y_sg13g2_nand4_1_C_Y_sg13g2_a221oi_1_C1/B2
+ VSS uo_out_sg13g2_dfrbpq_1_Q_5_D_sg13g2_a21oi_1_Y_A2_sg13g2_o21ai_1_Y_B1_sg13g2_or2_1_X_B_sg13g2_nand2_1_Y_A_sg13g2_a221oi_1_Y_B2_sg13g2_xor2_1_X_A_sg13g2_nand2_1_Y_A_sg13g2_nand3_1_B_Y_sg13g2_a21oi_1_A2/Y
+ sg13g2_nor2_1
Xserial_opcode\[1\]_sg13g2_nor2_1_A operation\[1\]_sg13g2_mux2_1_A0/A1 VDD serial_opcode\[1\]_sg13g2_nor2_1_A/Y
+ VSS operation\[0\]_sg13g2_mux2_1_A0/A1 sg13g2_nor2_1
Xserial_opcode\[2\]_sg13g2_dfrbpq_1_Q_D_sg13g2_o21ai_1_Y VSS VDD serial_opcode\[2\]_sg13g2_dfrbpq_1_Q/D
+ serial_opcode\[2\]_sg13g2_dfrbpq_1_Q_D_sg13g2_o21ai_1_Y/B1 ui_in[1] serial_opcode\[2\]_sg13g2_inv_1_A/Y
+ sg13g2_o21ai_1
Xuo_out_sg13g2_dfrbpq_1_Q_5_D_sg13g2_a21oi_1_Y_A2_sg13g2_o21ai_1_Y_B1_sg13g2_or2_1_X_B_sg13g2_nand2_1_Y_A_sg13g2_a221oi_1_Y_B2_sg13g2_xor2_1_X
+ uo_out_sg13g2_dfrbpq_1_Q_5_D_sg13g2_a21oi_1_Y_A2_sg13g2_o21ai_1_Y_B1_sg13g2_or2_1_X_B_sg13g2_nand2_1_Y_A_sg13g2_a221oi_1_Y/B2
+ VDD uo_out_sg13g2_dfrbpq_1_Q_5_D_sg13g2_a21oi_1_Y_A2_sg13g2_o21ai_1_Y_B1_sg13g2_or2_1_X_B_sg13g2_nand2_1_Y_B_sg13g2_a22oi_1_Y_B1_sg13g2_nand3_1_Y/B
+ uo_out_sg13g2_dfrbpq_1_Q_5_D_sg13g2_a21oi_1_Y_A2_sg13g2_o21ai_1_Y_B1_sg13g2_or2_1_X_B_sg13g2_nand2_1_Y_A_sg13g2_a221oi_1_Y_B2_sg13g2_xor2_1_X/A
+ VSS sg13g2_xor2_1
Xmisr\[1\]_sg13g2_inv_1_A_Y_sg13g2_xnor2_1_A_B_sg13g2_o21ai_1_Y_A2_sg13g2_nand3_1_Y_C_sg13g2_a22oi_1_Y_A2_sg13g2_xnor2_1_Y_B_sg13g2_a21oi_1_Y_B1_sg13g2_nor2b_1_Y
+ bist_a\[1\]_sg13g2_dfrbpq_1_Q/Q bist_a\[5\]_sg13g2_dfrbpq_1_Q/Q VDD misr\[1\]_sg13g2_inv_1_A_Y_sg13g2_xnor2_1_A_B_sg13g2_o21ai_1_Y_A2_sg13g2_nand3_1_Y_C_sg13g2_a22oi_1_Y_A2_sg13g2_xnor2_1_Y_B_sg13g2_a21oi_1_Y/B1
+ VSS sg13g2_nor2b_1
Xuo_out_sg13g2_dfrbpq_1_Q_4 VDD uo_out_sg13g2_dfrbpq_1_Q_4/D uo_out[6] clkbuf_5_27__f_clk/X
+ VSS rst_n sg13g2_dfrbpq_1
Xclkbuf_5_21__f_clk clkbuf_5_21__f_clk/X VSS clkbuf_4_10_0_clk/X VDD sg13g2_buf_4
Xscan_reg\[3\]_sg13g2_dfrbpq_1_Q VDD scan_reg\[3\]_sg13g2_dfrbpq_1_Q/D scan_reg\[3\]_sg13g2_nor2_1_A/A
+ clkbuf_5_7__f_clk/X VSS rst_n sg13g2_dfrbpq_1
Xserial_opcode\[1\]_sg13g2_nor2b_1_B_N operation\[0\]_sg13g2_mux2_1_A0/A1 operation\[1\]_sg13g2_mux2_1_A0/A1
+ VDD serial_opcode\[1\]_sg13g2_nor2b_1_B_N/Y VSS sg13g2_nor2b_1
Xcarry_flag_sg13g2_o21ai_1_A1_B1_sg13g2_nand2_1_Y_A_sg13g2_nand3_1_Y_B_sg13g2_nand3_1_C_Y_sg13g2_o21ai_1_B1_A2_sg13g2_nor3_1_Y_C_sg13g2_or3_1_C
+ VDD VSS carry_flag_sg13g2_o21ai_1_A1_B1_sg13g2_nand2_1_Y_A_sg13g2_nand3_1_Y_B_sg13g2_nand3_1_C_Y_sg13g2_o21ai_1_B1_A2_sg13g2_nor3_1_Y/C
+ carry_flag_sg13g2_o21ai_1_A1_B1_sg13g2_nand2_1_Y_A_sg13g2_nand3_1_Y_B_sg13g2_nand3_1_C_A_sg13g2_o21ai_1_B1/A2
+ carry_flag_sg13g2_o21ai_1_A1_B1_sg13g2_nand2_1_Y_A_sg13g2_nand3_1_Y_B_sg13g2_nand3_1_C_A_sg13g2_o21ai_1_B1/A1
+ carry_flag_sg13g2_o21ai_1_A1_B1_sg13g2_nand2_1_Y_A_sg13g2_nand3_1_Y_B_sg13g2_nand3_1_C_A_sg13g2_o21ai_1_B1_Y_sg13g2_o21ai_1_B1/A2
+ sg13g2_or3_1
Xfault_counter\[5\]_sg13g2_dfrbpq_1_Q VDD fault_counter\[5\]_sg13g2_dfrbpq_1_Q/D fault_counter\[5\]_sg13g2_dfrbpq_1_Q/Q
+ clkbuf_5_11__f_clk/X VSS rst_n sg13g2_dfrbpq_1
Xserial_a\[1\]_sg13g2_dfrbpq_1_Q_D_sg13g2_mux2_1_X serial_b\[2\]_sg13g2_xor2_1_A/B
+ serial_a\[1\]_sg13g2_dfrbpq_1_Q/D ui_in[1] VDD VSS serial_b\[1\]_sg13g2_xor2_1_A/B
+ sg13g2_mux2_1
Xscan_reg\[50\]_sg13g2_dfrbpq_1_Q_D_sg13g2_a221oi_1_Y scan_reg\[51\]_sg13g2_nor2_1_A/Y
+ scan_reg\[50\]_sg13g2_dfrbpq_1_Q/D scan_out_sg13g2_a22oi_1_A1/A2 scan_reg\[50\]_sg13g2_inv_1_A/Y
+ ui_in[3] VDD cycle_counter\[0\]_sg13g2_dfrbpq_1_Q/D VSS sg13g2_a221oi_1
Xmisr\[1\]_sg13g2_inv_1_A_Y_sg13g2_xnor2_1_A_B_sg13g2_o21ai_1_Y_A2_sg13g2_nand3_1_Y_C_sg13g2_a22oi_1_Y_A2_sg13g2_xnor2_1_Y_A_sg13g2_and2_1_X
+ misr\[1\]_sg13g2_inv_1_A_Y_sg13g2_xnor2_1_A_B_sg13g2_o21ai_1_Y_A2_sg13g2_nand3_1_Y_C_sg13g2_a22oi_1_Y_A2_sg13g2_xnor2_1_Y/A
+ VSS VDD misr\[1\]_sg13g2_inv_1_A_Y_sg13g2_xnor2_1_A_B_sg13g2_o21ai_1_Y_A2_sg13g2_nand3_1_Y_C_sg13g2_a22oi_1_Y_A2_sg13g2_xnor2_1_Y_A_sg13g2_and2_1_X/B
+ bist_a\[7\]_sg13g2_dfrbpq_1_Q_D_sg13g2_o21ai_1_Y_A1_sg13g2_nand2_1_A_Y_sg13g2_a221oi_1_B2_A2_sg13g2_xnor2_1_Y_B_sg13g2_and2_1_X/A
+ sg13g2_and2_1
Xserial_a\[5\]_sg13g2_dfrbpq_1_Q VDD serial_a\[5\]_sg13g2_dfrbpq_1_Q/D serial_a\[5\]_sg13g2_dfrbpq_1_Q/Q
+ clkbuf_5_21__f_clk/X VSS rst_n sg13g2_dfrbpq_1
Xoverflow_flag_sg13g2_dfrbpq_1_Q_D_sg13g2_inv_1_Y_A_sg13g2_o21ai_1_Y_B1_sg13g2_nand3_1_Y_A_sg13g2_nand2_1_Y_B_sg13g2_a21oi_1_Y_A2_sg13g2_o21ai_1_Y_B1_sg13g2_a22oi_1_B2_Y_sg13g2_nand4_1_C_Y_sg13g2_a221oi_1_C1
+ overflow_flag_sg13g2_dfrbpq_1_Q_D_sg13g2_inv_1_Y_A_sg13g2_o21ai_1_Y_B1_sg13g2_nand3_1_Y_A_sg13g2_nand2_1_Y_B_sg13g2_a21oi_1_Y_A2_sg13g2_o21ai_1_Y_B1_sg13g2_a22oi_1_B2_Y_sg13g2_nand4_1_C/Y
+ uo_out_sg13g2_dfrbpq_1_Q_D_sg13g2_a21oi_1_Y_B1_sg13g2_a21oi_1_Y_A1_sg13g2_nand3_1_Y_B_sg13g2_a221oi_1_Y_C1_sg13g2_o21ai_1_Y_A1_sg13g2_nor2_1_B_Y_sg13g2_a22oi_1_B2_Y_sg13g2_and2_1_B/A
+ overflow_flag_sg13g2_dfrbpq_1_Q_D_sg13g2_inv_1_Y_A_sg13g2_o21ai_1_Y_B1_sg13g2_nand3_1_Y_A_sg13g2_nand2_1_Y_B_sg13g2_a21oi_1_Y_A2_sg13g2_o21ai_1_Y_B1_sg13g2_a22oi_1_B2_Y_sg13g2_nand4_1_C_Y_sg13g2_a221oi_1_C1/B2
+ uo_out_sg13g2_dfrbpq_1_Q_D_sg13g2_a21oi_1_Y_B1_sg13g2_a21oi_1_Y_A1_sg13g2_nand3_1_Y_B_sg13g2_a221oi_1_Y/B2
+ uo_out_sg13g2_dfrbpq_1_Q_D_sg13g2_a21oi_1_Y_B1_sg13g2_a21oi_1_Y_A1_sg13g2_nand3_1_Y_A_sg13g2_nand2_1_Y/B
+ VDD serial_b\[6\]_sg13g2_and2_1_A/B VSS sg13g2_a221oi_1
Xscan_reg\[41\]_sg13g2_nor2_1_A_B_sg13g2_or2_1_X ui_in[3] VSS ui_in[6] scan_reg\[41\]_sg13g2_nor2_1_A/B
+ VDD sg13g2_or2_1
Xmisr\[1\]_sg13g2_inv_1_A_Y_sg13g2_xnor2_1_A_B_sg13g2_o21ai_1_Y_A2_sg13g2_nand3_1_Y_C_sg13g2_a22oi_1_Y_A2_sg13g2_xnor2_1_Y_A_sg13g2_and2_1_X_B_sg13g2_or2_1_X
+ bist_a\[2\]_sg13g2_dfrbpq_1_Q/Q VSS lfsr\[6\]_sg13g2_mux2_1_A1/A0 misr\[1\]_sg13g2_inv_1_A_Y_sg13g2_xnor2_1_A_B_sg13g2_o21ai_1_Y_A2_sg13g2_nand3_1_Y_C_sg13g2_a22oi_1_Y_A2_sg13g2_xnor2_1_Y_A_sg13g2_and2_1_X/B
+ VDD sg13g2_or2_1
Xzero_flag_sg13g2_nand2_1_A_B_sg13g2_inv_1_Y zero_flag_sg13g2_nand2_1_A/B ui_in[2]
+ VSS VDD sg13g2_inv_1
Xmisr\[1\]_sg13g2_dfrbpq_1_Q_D_sg13g2_a22oi_1_Y_B2_sg13g2_o21ai_1_Y_A2_sg13g2_a22oi_1_Y_B2_sg13g2_a21oi_1_Y
+ VDD VSS misr\[1\]_sg13g2_dfrbpq_1_Q_D_sg13g2_a22oi_1_Y_B2_sg13g2_o21ai_1_Y_A2_sg13g2_a22oi_1_Y/A2
+ uo_out_sg13g2_dfrbpq_1_Q_5_D_sg13g2_a21oi_1_Y_A2_sg13g2_o21ai_1_Y_A2_sg13g2_mux2_1_X/A0
+ misr\[1\]_sg13g2_dfrbpq_1_Q_D_sg13g2_a22oi_1_Y_B2_sg13g2_o21ai_1_Y_A2_sg13g2_a22oi_1_Y_B2_sg13g2_a21oi_1_Y/B1
+ misr\[1\]_sg13g2_dfrbpq_1_Q_D_sg13g2_a22oi_1_Y_B2_sg13g2_o21ai_1_Y_A2_sg13g2_a22oi_1_Y/B2
+ sg13g2_a21oi_1
Xmisr\[0\]_sg13g2_dfrbpq_1_Q_D_sg13g2_a22oi_1_Y_B2_sg13g2_o21ai_1_Y VSS VDD misr\[0\]_sg13g2_dfrbpq_1_Q_D_sg13g2_a22oi_1_Y/B2
+ misr\[0\]_sg13g2_dfrbpq_1_Q_D_sg13g2_a22oi_1_Y_B2_sg13g2_o21ai_1_Y/B1 misr\[0\]_sg13g2_dfrbpq_1_Q_D_sg13g2_a22oi_1_Y_B2_sg13g2_o21ai_1_Y/A2
+ misr\[7\]_sg13g2_dfrbpq_1_Q/Q sg13g2_o21ai_1
Xoverflow_flag_sg13g2_dfrbpq_1_Q_D_sg13g2_inv_1_Y_A_sg13g2_o21ai_1_Y_B1_sg13g2_nand3_1_Y_C_sg13g2_a21oi_1_Y_A1_sg13g2_o21ai_1_A2_B1_sg13g2_o21ai_1_A1_Y_sg13g2_nor2_1_B_Y_sg13g2_o21ai_1_B1_A1_sg13g2_o21ai_1_B1
+ VSS VDD uo_out_sg13g2_dfrbpq_1_Q_D_sg13g2_a21oi_1_Y_B1_sg13g2_a21oi_1_Y_A1_sg13g2_nand3_1_Y_B_sg13g2_a221oi_1_Y/B2
+ overflow_flag_sg13g2_dfrbpq_1_Q_D_sg13g2_inv_1_Y_A_sg13g2_o21ai_1_Y_B1_sg13g2_nand3_1_Y_C_sg13g2_a21oi_1_Y_A1_sg13g2_o21ai_1_A2_B1_sg13g2_o21ai_1_A1_Y_sg13g2_nor2_1_B_Y_sg13g2_o21ai_1_B1/A1
+ carry_flag_sg13g2_o21ai_1_A1_B1_sg13g2_nand2_1_Y_A_sg13g2_nand3_1_Y_B_sg13g2_nand3_1_Y_A_sg13g2_nor3_1_A/Y
+ uo_out_sg13g2_dfrbpq_1_Q_3_D_sg13g2_o21ai_1_Y_B1_sg13g2_nand2_1_Y_B_sg13g2_a22oi_1_Y_A1_sg13g2_a221oi_1_Y_C1_sg13g2_or4_1_X_D_sg13g2_nor3_1_Y/B
+ sg13g2_o21ai_1
Xoverflow_flag_sg13g2_dfrbpq_1_Q_D_sg13g2_inv_1_Y_A_sg13g2_o21ai_1_Y_B1_sg13g2_nand3_1_Y_A_sg13g2_and4_1_A_X_sg13g2_nand3_1_B
+ VDD negative_flag_sg13g2_dfrbpq_1_Q_D_sg13g2_a21oi_1_Y_A2_sg13g2_o21ai_1_Y_B1_sg13g2_nand2b_1_Y/A_N
+ overflow_flag_sg13g2_dfrbpq_1_Q_D_sg13g2_inv_1_Y_A_sg13g2_o21ai_1_Y_B1_sg13g2_nand3_1_Y_A_sg13g2_and4_1_A/X
+ overflow_flag_sg13g2_dfrbpq_1_Q_D_sg13g2_inv_1_Y_A_sg13g2_o21ai_1_Y_B1_sg13g2_nand3_1_Y_A_sg13g2_and4_1_A_X_sg13g2_nand3_1_B/C
+ overflow_flag_sg13g2_dfrbpq_1_Q_D_sg13g2_inv_1_Y_A_sg13g2_o21ai_1_Y_B1_sg13g2_nand3_1_Y_A_sg13g2_and4_1_A_X_sg13g2_nand3_1_B/A
+ VSS sg13g2_nand3_1
Xbist_state\[3\]_sg13g2_dfrbpq_1_Q VDD bist_state\[3\]_sg13g2_dfrbpq_1_Q/D bist_fault_sg13g2_o21ai_1_A2/B1
+ clkbuf_5_6__f_clk/X VSS rst_n sg13g2_dfrbpq_1
Xcarry_flag_sg13g2_o21ai_1_A1_B1_sg13g2_nand2_1_Y_B_sg13g2_a21oi_1_Y_A2_sg13g2_a21oi_1_Y_B1_sg13g2_o21ai_1_B1_Y_sg13g2_a221oi_1_B1_1_B2_sg13g2_xnor2_1_Y_B_sg13g2_o21ai_1_Y_A1_sg13g2_nand2b_1_A_N_Y_sg13g2_nand4_1_C_A_sg13g2_a22oi_1_Y
+ carry_flag_sg13g2_o21ai_1_A1_B1_sg13g2_nand2_1_Y_B_sg13g2_a21oi_1_Y_A2_sg13g2_a21oi_1_Y_B1_sg13g2_o21ai_1_B1_Y_sg13g2_a221oi_1_B1_1_B2_sg13g2_xnor2_1_Y_B_sg13g2_o21ai_1_Y_A1_sg13g2_nand2b_1_A_N_Y_sg13g2_nand4_1_C/A
+ overflow_flag_sg13g2_dfrbpq_1_Q_D_sg13g2_inv_1_Y_A_sg13g2_o21ai_1_Y_B1_sg13g2_nand3_1_Y_A_sg13g2_and4_1_A_D_sg13g2_a221oi_1_Y/A2
+ VDD serial_opcode\[0\]_sg13g2_o21ai_1_A1/Y serial_b\[0\]_sg13g2_xnor2_1_B/A VSS
+ serial_b\[2\]_sg13g2_xor2_1_A/B sg13g2_a22oi_1
Xuio_out_sg13g2_nand2_1_Y_2_B_sg13g2_a22oi_1_Y uio_out_sg13g2_nand2_1_Y_2/B misr\[1\]_sg13g2_a22oi_1_B2/A2
+ VDD misr\[4\]_sg13g2_a22oi_1_B2/A2 uo_out[7] VSS fault_counter\[2\]_sg13g2_dfrbpq_1_Q/Q
+ sg13g2_a22oi_1
Xmisr\[1\]_sg13g2_inv_1_A_Y_sg13g2_xnor2_1_A_B_sg13g2_o21ai_1_Y_B1_sg13g2_nand4_1_Y_A_sg13g2_nand2b_1_Y
+ VSS uio_in[2] misr\[1\]_sg13g2_inv_1_A_Y_sg13g2_xnor2_1_A_B_sg13g2_o21ai_1_Y_B1_sg13g2_nand4_1_Y/A
+ uio_in[1] VDD sg13g2_nand2b_1
Xbist_a\[4\]_sg13g2_dfrbpq_1_Q VDD bist_a\[4\]_sg13g2_dfrbpq_1_Q/D bist_a\[4\]_sg13g2_dfrbpq_1_Q/Q
+ clkload0/A VSS rst_n sg13g2_dfrbpq_1
Xuo_out_sg13g2_dfrbpq_1_Q_6_D_sg13g2_a21oi_1_Y_A2_sg13g2_a21o_1_X_A2_sg13g2_and2_1_X_A_sg13g2_a221oi_1_Y_B2_sg13g2_and2_1_X_B_sg13g2_o21ai_1_Y
+ VSS VDD uo_out_sg13g2_dfrbpq_1_Q_6_D_sg13g2_a21oi_1_Y_A2_sg13g2_a21o_1_X_A2_sg13g2_and2_1_X_A_sg13g2_a221oi_1_Y_B2_sg13g2_and2_1_X/B
+ uo_out_sg13g2_dfrbpq_1_Q_6_D_sg13g2_a21oi_1_Y_A2_sg13g2_a21o_1_X_A2_sg13g2_and2_1_X_A_sg13g2_a221oi_1_Y_B2_sg13g2_and2_1_X_B_sg13g2_o21ai_1_Y/B1
+ uo_out_sg13g2_dfrbpq_1_Q_6_D_sg13g2_a21oi_1_Y_A2_sg13g2_a21o_1_X_A2_sg13g2_and2_1_X_A_sg13g2_a221oi_1_Y_B2_sg13g2_and2_1_X_B_sg13g2_o21ai_1_Y/A2
+ uo_out_sg13g2_dfrbpq_1_Q_6_D_sg13g2_a21oi_1_Y_A2_sg13g2_a21o_1_X_A2_sg13g2_and2_1_X_A_sg13g2_a221oi_1_Y_B2_sg13g2_and2_1_X_B_sg13g2_o21ai_1_Y/A1
+ sg13g2_o21ai_1
Xscan_reg\[44\]_sg13g2_inv_1_A scan_reg\[44\]_sg13g2_inv_1_A/Y scan_reg\[44\]_sg13g2_inv_1_A/A
+ VSS VDD sg13g2_inv_1
Xuo_out_sg13g2_dfrbpq_1_Q_5_D_sg13g2_a21oi_1_Y_A2_sg13g2_o21ai_1_Y_A2_sg13g2_mux2_1_X
+ uo_out_sg13g2_dfrbpq_1_Q_5_D_sg13g2_a21oi_1_Y_A2_sg13g2_o21ai_1_Y_A2_sg13g2_mux2_1_X/A1
+ uo_out_sg13g2_dfrbpq_1_Q_5_D_sg13g2_a21oi_1_Y_A2_sg13g2_o21ai_1_Y/A2 uo_out_sg13g2_dfrbpq_1_Q_5_D_sg13g2_a21oi_1_Y_A2_sg13g2_o21ai_1_Y_B1_sg13g2_or2_1_X/B
+ VDD VSS uo_out_sg13g2_dfrbpq_1_Q_5_D_sg13g2_a21oi_1_Y_A2_sg13g2_o21ai_1_Y_A2_sg13g2_mux2_1_X/A0
+ sg13g2_mux2_1
Xclkbuf_5_2__f_clk clkbuf_5_2__f_clk/X VSS clkbuf_4_1_0_clk/X VDD sg13g2_buf_4
Xnegative_flag_sg13g2_dfrbpq_1_Q_D_sg13g2_a21oi_1_Y VDD VSS negative_flag_sg13g2_dfrbpq_1_Q_D_sg13g2_a21oi_1_Y/A2
+ ui_in[2] negative_flag_sg13g2_dfrbpq_1_Q_D_sg13g2_a21oi_1_Y/B1 negative_flag_sg13g2_dfrbpq_1_Q/D
+ sg13g2_a21oi_1
Xmisr\[1\]_sg13g2_inv_1_A_Y_sg13g2_xnor2_1_A_B_sg13g2_o21ai_1_Y_A2_sg13g2_nand3_1_Y_C_sg13g2_a22oi_1_Y_A2_sg13g2_xnor2_1_Y_B_sg13g2_a21oi_1_Y_A2_sg13g2_nor2b_1_Y
+ bist_a\[0\]_sg13g2_dfrbpq_1_Q/Q bist_a\[4\]_sg13g2_dfrbpq_1_Q/Q VDD misr\[1\]_sg13g2_inv_1_A_Y_sg13g2_xnor2_1_A_B_sg13g2_o21ai_1_Y_A2_sg13g2_nand3_1_Y_C_sg13g2_a22oi_1_Y_A2_sg13g2_xnor2_1_Y_B_sg13g2_a21oi_1_Y/A2
+ VSS sg13g2_nor2b_1
Xuo_out_sg13g2_dfrbpq_1_Q_6_D_sg13g2_a21oi_1_Y VDD VSS uo_out_sg13g2_dfrbpq_1_Q_6_D_sg13g2_a21oi_1_Y/A2
+ ui_in[2] uo_out_sg13g2_dfrbpq_1_Q_6_D_sg13g2_a21oi_1_Y/B1 uo_out_sg13g2_dfrbpq_1_Q_6/D
+ sg13g2_a21oi_1
Xoperation\[3\]_sg13g2_dfrbpq_1_Q_D_sg13g2_a21oi_1_Y_A1_sg13g2_a21oi_1_A1_Y_sg13g2_nor2_1_B_Y_sg13g2_a21oi_1_B1
+ VDD VSS serial_opcode\[0\]_sg13g2_o21ai_1_A1/Y serial_b\[1\]_sg13g2_xor2_1_A/B operation\[3\]_sg13g2_dfrbpq_1_Q_D_sg13g2_a21oi_1_Y_A1_sg13g2_a21oi_1_A1_Y_sg13g2_nor2_1_B/Y
+ operation\[3\]_sg13g2_dfrbpq_1_Q_D_sg13g2_a21oi_1_Y_A1_sg13g2_a21oi_1_A1_Y_sg13g2_nor2_1_B_Y_sg13g2_a21oi_1_B1/Y
+ sg13g2_a21oi_1
Xmisr\[3\]_sg13g2_dfrbpq_1_Q_D_sg13g2_o21ai_1_Y_A2_sg13g2_xnor2_1_Y_B_sg13g2_a22oi_1_Y_B1_sg13g2_nand2b_1_Y
+ VSS negative_flag_sg13g2_dfrbpq_1_Q_D_sg13g2_a21oi_1_Y_A2_sg13g2_o21ai_1_Y_A2_sg13g2_o21ai_1_Y/A1
+ misr\[3\]_sg13g2_dfrbpq_1_Q_D_sg13g2_o21ai_1_Y_A2_sg13g2_xnor2_1_Y_B_sg13g2_a22oi_1_Y/B1
+ misr\[1\]_sg13g2_inv_1_A_Y_sg13g2_xnor2_1_A_B_sg13g2_o21ai_1_Y/A2 VDD sg13g2_nand2b_1
Xclkbuf_4_2_0_clk clkbuf_4_2_0_clk/X VSS clkbuf_0_clk/X VDD sg13g2_buf_4
Xscan_reg\[24\]_sg13g2_dfrbpq_1_Q VDD scan_reg\[24\]_sg13g2_dfrbpq_1_Q/D scan_reg\[24\]_sg13g2_inv_1_A/A
+ clkbuf_5_30__f_clk/X VSS rst_n sg13g2_dfrbpq_1
Xscan_reg\[4\]_sg13g2_inv_1_A scan_reg\[4\]_sg13g2_inv_1_A/Y scan_reg\[4\]_sg13g2_inv_1_A/A
+ VSS VDD sg13g2_inv_1
Xbist_fault_sg13g2_dfrbpq_1_Q_D_sg13g2_nor3_1_Y bist_fault_sg13g2_dfrbpq_1_Q_D_sg13g2_nor3_1_Y/A
+ bist_fault_sg13g2_dfrbpq_1_Q/D bist_fault_sg13g2_nor2_1_B/Y bist_fault_sg13g2_nor2b_1_A/Y
+ VDD VSS sg13g2_nor3_1
Xuo_out_sg13g2_dfrbpq_1_Q_6_D_sg13g2_a21oi_1_Y_A2_sg13g2_a21o_1_X_A2_sg13g2_and2_1_X_A_sg13g2_a221oi_1_Y_C1_sg13g2_nand3_1_Y_C_sg13g2_a221oi_1_Y_B2_sg13g2_inv_1_Y
+ uo_out_sg13g2_dfrbpq_1_Q_6_D_sg13g2_a21oi_1_Y_A2_sg13g2_a21o_1_X_A2_sg13g2_and2_1_X_A_sg13g2_a221oi_1_Y_C1_sg13g2_nand3_1_Y_C_sg13g2_a221oi_1_Y/B2
+ serial_b\[4\]_sg13g2_nand2_1_A/Y VSS VDD sg13g2_inv_1
Xcarry_flag_sg13g2_o21ai_1_A1_B1_sg13g2_nand2_1_Y_B_sg13g2_a21oi_1_Y_A2_sg13g2_a21oi_1_Y_B1_sg13g2_o21ai_1_B1_Y_sg13g2_a221oi_1_B1_1_B2_sg13g2_xnor2_1_Y_B_sg13g2_o21ai_1_Y_B1_sg13g2_nand2_1_Y
+ carry_flag_sg13g2_o21ai_1_A1_B1_sg13g2_nand2_1_Y_B_sg13g2_a21oi_1_Y_A2_sg13g2_a21oi_1_Y_B1_sg13g2_o21ai_1_B1_Y_sg13g2_a221oi_1_B1_1_B2_sg13g2_xnor2_1_Y_B_sg13g2_o21ai_1_Y/B1
+ VDD serial_b\[1\]_sg13g2_xor2_1_A/A VSS serial_b\[1\]_sg13g2_xor2_1_A/B sg13g2_nand2_1
Xscan_reg\[55\]_sg13g2_o21ai_1_A1_B1_sg13g2_nand2b_1_Y VSS cycle_counter\[5\]_sg13g2_dfrbpq_1_Q/Q
+ scan_reg\[55\]_sg13g2_o21ai_1_A1/B1 ui_in[3] VDD sg13g2_nand2b_1
Xscan_reg\[44\]_sg13g2_dfrbpq_1_Q VDD scan_reg\[44\]_sg13g2_dfrbpq_1_Q/D scan_reg\[44\]_sg13g2_inv_1_A/A
+ clkbuf_5_8__f_clk/X VSS rst_n sg13g2_dfrbpq_1
Xoverflow_flag_sg13g2_dfrbpq_1_Q_D_sg13g2_inv_1_Y_A_sg13g2_o21ai_1_Y_B1_sg13g2_nand3_1_Y_A_sg13g2_nand2_1_Y_B_sg13g2_a21oi_1_Y_A2_sg13g2_o21ai_1_Y_B1_sg13g2_and2_1_X_B_sg13g2_or2_1_X
+ serial_b\[6\]_sg13g2_and2_1_A/A VSS serial_b\[6\]_sg13g2_and2_1_A/B overflow_flag_sg13g2_dfrbpq_1_Q_D_sg13g2_inv_1_Y_A_sg13g2_o21ai_1_Y_B1_sg13g2_nand3_1_Y_A_sg13g2_nand2_1_Y_B_sg13g2_a21oi_1_Y_A2_sg13g2_o21ai_1_Y_B1_sg13g2_and2_1_X/B
+ VDD sg13g2_or2_1
Xuo_out_sg13g2_dfrbpq_1_Q_5 VDD uo_out_sg13g2_dfrbpq_1_Q_5/D uo_out[5] clkbuf_5_27__f_clk/X
+ VSS rst_n sg13g2_dfrbpq_1
Xoverflow_flag_sg13g2_dfrbpq_1_Q_D_sg13g2_inv_1_Y_A_sg13g2_o21ai_1_Y_B1_sg13g2_nand3_1_Y_A_sg13g2_and4_1_A_D_sg13g2_a221oi_1_Y
+ overflow_flag_sg13g2_dfrbpq_1_Q_D_sg13g2_inv_1_Y_A_sg13g2_o21ai_1_Y_B1_sg13g2_nand3_1_Y_A_sg13g2_and4_1_A_D_sg13g2_a221oi_1_Y/C1
+ overflow_flag_sg13g2_dfrbpq_1_Q_D_sg13g2_inv_1_Y_A_sg13g2_o21ai_1_Y_B1_sg13g2_nand3_1_Y_A_sg13g2_and4_1_A/D
+ overflow_flag_sg13g2_dfrbpq_1_Q_D_sg13g2_inv_1_Y_A_sg13g2_o21ai_1_Y_B1_sg13g2_nand3_1_Y_A_sg13g2_nand2_1_Y_B_sg13g2_a21oi_1_Y/B1
+ overflow_flag_sg13g2_dfrbpq_1_Q_D_sg13g2_inv_1_Y_A_sg13g2_o21ai_1_Y_B1_sg13g2_nand3_1_Y_A_sg13g2_and4_1_A_D_sg13g2_a221oi_1_Y/B1
+ overflow_flag_sg13g2_dfrbpq_1_Q_D_sg13g2_inv_1_Y_A_sg13g2_o21ai_1_Y_B1_sg13g2_nand3_1_Y_A_sg13g2_and4_1_A_D_sg13g2_a221oi_1_Y/A2
+ VDD serial_b\[6\]_sg13g2_and2_1_A/B VSS sg13g2_a221oi_1
Xoverflow_flag_sg13g2_dfrbpq_1_Q_D_sg13g2_inv_1_Y_A_sg13g2_o21ai_1_Y_B1_sg13g2_nand3_1_Y_C_sg13g2_a21oi_1_Y_A1_sg13g2_o21ai_1_A2_B1_sg13g2_o21ai_1_A1_Y_sg13g2_nor2_1_B_A_sg13g2_nand3_1_Y
+ VDD overflow_flag_sg13g2_dfrbpq_1_Q_D_sg13g2_inv_1_Y_A_sg13g2_o21ai_1_Y_B1_sg13g2_nand3_1_Y_C_sg13g2_a21oi_1_Y_A1_sg13g2_o21ai_1_A2_B1_sg13g2_o21ai_1_A1_Y_sg13g2_nor2_1_B/A
+ overflow_flag_sg13g2_dfrbpq_1_Q_D_sg13g2_inv_1_Y_A_sg13g2_o21ai_1_Y_B1_sg13g2_nand3_1_Y_C_sg13g2_a21oi_1_Y_A1_sg13g2_o21ai_1_A2_B1_sg13g2_o21ai_1_A1_Y_sg13g2_nor2_1_B_A_sg13g2_nand3_1_Y/B
+ overflow_flag_sg13g2_dfrbpq_1_Q_D_sg13g2_inv_1_Y_A_sg13g2_o21ai_1_Y_B1_sg13g2_nand3_1_Y_C_sg13g2_a21oi_1_Y_A1_sg13g2_o21ai_1_A2_B1_sg13g2_o21ai_1_A1_Y_sg13g2_nor2_1_B_A_sg13g2_nand3_1_Y/C
+ overflow_flag_sg13g2_dfrbpq_1_Q_D_sg13g2_inv_1_Y_A_sg13g2_o21ai_1_Y_B1_sg13g2_nand3_1_Y_C_sg13g2_a21oi_1_Y_A1_sg13g2_o21ai_1_A2_B1_sg13g2_o21ai_1_A1_Y_sg13g2_nor2_1_B_A_sg13g2_nand3_1_Y/A
+ VSS sg13g2_nand3_1
Xuo_out_sg13g2_dfrbpq_1_Q_1_D_sg13g2_a21oi_1_Y_A2_sg13g2_o21ai_1_Y_A1_sg13g2_o21ai_1_Y_B1_sg13g2_nand2_1_Y
+ uo_out_sg13g2_dfrbpq_1_Q_1_D_sg13g2_a21oi_1_Y_A2_sg13g2_o21ai_1_Y_A1_sg13g2_o21ai_1_Y/B1
+ VDD uo_out_sg13g2_dfrbpq_1_Q_5_D_sg13g2_a21oi_1_Y_A2_sg13g2_o21ai_1_Y_A2_sg13g2_mux2_1_X/A0
+ VSS uo_out_sg13g2_dfrbpq_1_Q_1_D_sg13g2_a21oi_1_Y_A2_sg13g2_o21ai_1_Y_B1_sg13g2_nand2b_1_Y/B
+ sg13g2_nand2_1
Xuo_out_sg13g2_dfrbpq_1_Q_3_D_sg13g2_o21ai_1_Y_B1_sg13g2_nand2_1_Y_B_sg13g2_a22oi_1_Y_A1_sg13g2_a221oi_1_Y_C1_sg13g2_or4_1_X_D_sg13g2_nor3_1_Y_B_sg13g2_or2_1_X
+ serial_opcode\[2\]_sg13g2_nand2_1_A/Y VSS serial_opcode\[2\]_sg13g2_nor3_1_A/C uo_out_sg13g2_dfrbpq_1_Q_3_D_sg13g2_o21ai_1_Y_B1_sg13g2_nand2_1_Y_B_sg13g2_a22oi_1_Y_A1_sg13g2_a221oi_1_Y_C1_sg13g2_or4_1_X_D_sg13g2_nor3_1_Y/B
+ VDD sg13g2_or2_1
Xuo_out_sg13g2_dfrbpq_1_Q_6_D_sg13g2_a21oi_1_Y_A2_sg13g2_a21o_1_X_A2_sg13g2_and2_1_X_A_sg13g2_a221oi_1_Y_C1_sg13g2_nand3_1_Y_C_sg13g2_a221oi_1_Y
+ uo_out_sg13g2_dfrbpq_1_Q_6_D_sg13g2_a21oi_1_Y_A2_sg13g2_a21o_1_X_A2_sg13g2_and2_1_X_A_sg13g2_a221oi_1_Y_C1_sg13g2_nand3_1_Y_C_sg13g2_a221oi_1_Y/C1
+ uo_out_sg13g2_dfrbpq_1_Q_6_D_sg13g2_a21oi_1_Y_A2_sg13g2_a21o_1_X_A2_sg13g2_and2_1_X_A_sg13g2_a221oi_1_Y_C1_sg13g2_nand3_1_Y/C
+ uo_out_sg13g2_dfrbpq_1_Q_6_D_sg13g2_a21oi_1_Y_A2_sg13g2_a21o_1_X_A2_sg13g2_and2_1_X_A_sg13g2_a221oi_1_Y_C1_sg13g2_nand3_1_Y_C_sg13g2_a221oi_1_Y/B2
+ overflow_flag_sg13g2_dfrbpq_1_Q_D_sg13g2_inv_1_Y_A_sg13g2_o21ai_1_Y_B1_sg13g2_nand3_1_Y_A_sg13g2_and4_1_A_C_sg13g2_o21ai_1_Y/A2
+ uo_out_sg13g2_dfrbpq_1_Q_6_D_sg13g2_a21oi_1_Y_A2_sg13g2_a21o_1_X_A2_sg13g2_and2_1_X_A_sg13g2_a221oi_1_Y_C1_sg13g2_nand3_1_Y_C_sg13g2_a221oi_1_Y/A2
+ VDD uo_out_sg13g2_dfrbpq_1_Q_6_D_sg13g2_a21oi_1_Y_A2_sg13g2_a21o_1_X_A2_sg13g2_and2_1_X_A_sg13g2_a221oi_1_Y_B2_sg13g2_and2_1_X_B_sg13g2_o21ai_1_Y/B1
+ VSS sg13g2_a221oi_1
Xuo_out_sg13g2_dfrbpq_1_Q_3_D_sg13g2_o21ai_1_Y_B1_sg13g2_nand2_1_Y uo_out_sg13g2_dfrbpq_1_Q_3_D_sg13g2_o21ai_1_Y/B1
+ VDD ui_in[2] VSS uo_out_sg13g2_dfrbpq_1_Q_3_D_sg13g2_o21ai_1_Y_B1_sg13g2_nand2_1_Y/B
+ sg13g2_nand2_1
Xscan_reg\[9\]_sg13g2_inv_1_A scan_reg\[9\]_sg13g2_inv_1_A/Y scan_reg\[9\]_sg13g2_inv_1_A/A
+ VSS VDD sg13g2_inv_1
Xbist_pattern_count\[3\]_sg13g2_dfrbpq_1_Q VDD bist_pattern_count\[3\]_sg13g2_dfrbpq_1_Q/D
+ bist_pattern_count\[3\]_sg13g2_nor2_1_A/A clkbuf_5_2__f_clk/X VSS rst_n sg13g2_dfrbpq_1
Xscan_reg\[44\]_sg13g2_dfrbpq_1_Q_D_sg13g2_a221oi_1_Y scan_reg\[45\]_sg13g2_nor2_1_A/Y
+ scan_reg\[44\]_sg13g2_dfrbpq_1_Q/D scan_out_sg13g2_a22oi_1_A1/A2 scan_reg\[44\]_sg13g2_inv_1_A/Y
+ scan_reg\[44\]_sg13g2_dfrbpq_1_Q_D_sg13g2_a221oi_1_Y/A2 VDD ui_in[3] VSS sg13g2_a221oi_1
Xscan_reg\[35\]_sg13g2_inv_1_A scan_reg\[35\]_sg13g2_inv_1_A/Y scan_reg\[35\]_sg13g2_inv_1_A/A
+ VSS VDD sg13g2_inv_1
Xuo_out_sg13g2_dfrbpq_1_Q_4_D_sg13g2_a21oi_1_Y_A2_sg13g2_a21o_1_X uo_out_sg13g2_dfrbpq_1_Q_4_D_sg13g2_a21oi_1_Y_A2_sg13g2_a21o_1_X/B1
+ uo_out_sg13g2_dfrbpq_1_Q_4_D_sg13g2_a21oi_1_Y/A2 VDD VSS uo_out_sg13g2_dfrbpq_1_Q_4_D_sg13g2_a21oi_1_Y_A2_sg13g2_a21o_1_X/A1
+ uo_out_sg13g2_dfrbpq_1_Q_4_D_sg13g2_a21oi_1_Y_A2_sg13g2_a21o_1_X/A2 sg13g2_a21o_1
Xuo_out_sg13g2_dfrbpq_1_Q_5_D_sg13g2_a21oi_1_Y_A2_sg13g2_o21ai_1_Y_B1_sg13g2_or2_1_X_B_sg13g2_nand2_1_Y_A_sg13g2_a221oi_1_Y_B2_sg13g2_xor2_1_X_A_sg13g2_nand2_1_Y_A_sg13g2_nand3_1_B_Y_sg13g2_nand3_1_C
+ VDD carry_flag_sg13g2_o21ai_1_A1_B1_sg13g2_nand2_1_Y_A_sg13g2_nand3_1_Y_B_sg13g2_nand3_1_Y/C
+ serial_b\[5\]_sg13g2_nand2b_1_B/Y uo_out_sg13g2_dfrbpq_1_Q_5_D_sg13g2_a21oi_1_Y_A2_sg13g2_o21ai_1_Y_B1_sg13g2_or2_1_X_B_sg13g2_nand2_1_Y_A_sg13g2_a221oi_1_Y_B2_sg13g2_xor2_1_X_A_sg13g2_nand2_1_Y_A_sg13g2_nand3_1_B/Y
+ carry_flag_sg13g2_o21ai_1_A1_B1_sg13g2_nand2_1_Y_A_sg13g2_nand3_1_Y_B_sg13g2_nand3_1_C_Y_sg13g2_o21ai_1_B1_A2_sg13g2_nor3_1_Y_C_sg13g2_nor4_1_Y_D_sg13g2_nand2_1_Y/A
+ VSS sg13g2_nand3_1
Xoperand_a\[3\]_sg13g2_nand2b_1_A_N VSS operand_a\[3\]_sg13g2_mux2_1_A0/A0 scan_reg\[3\]_sg13g2_o21ai_1_A1/B1
+ ui_in[3] VDD sg13g2_nand2b_1
Xbist_a\[7\]_sg13g2_dfrbpq_1_Q_D_sg13g2_o21ai_1_Y_A1_sg13g2_o21ai_1_A1_B1_sg13g2_nand4_1_C_B_sg13g2_nand2_1_Y
+ bist_a\[7\]_sg13g2_dfrbpq_1_Q_D_sg13g2_o21ai_1_Y_A1_sg13g2_o21ai_1_A1_B1_sg13g2_nand4_1_C/B
+ VDD bist_a\[5\]_sg13g2_dfrbpq_1_Q/Q VSS misr\[3\]_sg13g2_dfrbpq_1_Q_D_sg13g2_o21ai_1_Y_A2_sg13g2_xnor2_1_Y_B_sg13g2_a22oi_1_Y_A2_sg13g2_a21oi_1_Y/A2
+ sg13g2_nand2_1
Xcarry_flag_sg13g2_o21ai_1_A1_B1_sg13g2_nand2_1_Y_B_sg13g2_a21oi_1_Y_A2_sg13g2_a21oi_1_Y_B1_sg13g2_o21ai_1_B1_Y_sg13g2_a221oi_1_B1_1_Y_sg13g2_or4_1_C_X_sg13g2_a221oi_1_C1
+ carry_flag_sg13g2_o21ai_1_A1_B1_sg13g2_nand2_1_Y_B_sg13g2_a21oi_1_Y_A2_sg13g2_a21oi_1_Y_B1_sg13g2_o21ai_1_B1_Y_sg13g2_a221oi_1_B1_1_Y_sg13g2_or4_1_C/X
+ uo_out_sg13g2_dfrbpq_1_Q_1_D_sg13g2_a21oi_1_Y_A2_sg13g2_o21ai_1_Y_B1_sg13g2_nand2b_1_Y/B
+ serial_b\[2\]_sg13g2_xor2_1_A/A uo_out_sg13g2_dfrbpq_1_Q_6_D_sg13g2_a21oi_1_Y_A2_sg13g2_a21o_1_X_A2_sg13g2_and2_1_X_B_sg13g2_a22oi_1_Y/A2
+ uo_out_sg13g2_dfrbpq_1_Q_D_sg13g2_a21oi_1_Y_B1_sg13g2_a21oi_1_Y_A1_sg13g2_nand3_1_Y_A_sg13g2_nand2_1_Y/B
+ VDD serial_b\[2\]_sg13g2_xor2_1_A/B VSS sg13g2_a221oi_1
Xscan_reg\[6\]_sg13g2_dfrbpq_1_Q_D_sg13g2_a21oi_1_Y VDD VSS scan_out_sg13g2_a22oi_1_A1/B1
+ scan_reg\[7\]_sg13g2_inv_1_A/Y scan_reg\[6\]_sg13g2_o21ai_1_A1_1/Y scan_reg\[6\]_sg13g2_dfrbpq_1_Q/D
+ sg13g2_a21oi_1
Xmisr\[1\]_sg13g2_dfrbpq_1_Q_D_sg13g2_a22oi_1_Y_B2_sg13g2_o21ai_1_Y_A2_sg13g2_a22oi_1_Y_A2_sg13g2_and2_1_X_A_sg13g2_a21oi_1_Y_A1_sg13g2_nor2_1_A
+ misr\[1\]_sg13g2_dfrbpq_1_Q_D_sg13g2_a22oi_1_Y_B2_sg13g2_o21ai_1_Y_A2_sg13g2_a22oi_1_Y_A2_sg13g2_and2_1_X_A_sg13g2_a21oi_1_Y/A1
+ VDD misr\[4\]_sg13g2_inv_1_A_Y_sg13g2_xnor2_1_A_B_sg13g2_o21ai_1_Y_B1_sg13g2_or2_1_X_A_sg13g2_nand3_1_Y_C_sg13g2_a21oi_1_Y_B1_sg13g2_a221oi_1_Y/A2
+ VSS bist_a\[7\]_sg13g2_dfrbpq_1_Q_D_sg13g2_o21ai_1_Y_A1_sg13g2_o21ai_1_A1_Y_sg13g2_nand2b_1_A_N_B_sg13g2_a21oi_1_Y/A1
+ sg13g2_nor2_1
Xoperation\[3\]_sg13g2_dfrbpq_1_Q_D_sg13g2_a21oi_1_Y_A1_sg13g2_a21oi_1_A1_Y_sg13g2_nor2_1_B_Y_sg13g2_a21oi_1_B1_Y_sg13g2_nand3_1_A_C_sg13g2_nand4_1_Y
+ VDD operation\[3\]_sg13g2_dfrbpq_1_Q_D_sg13g2_a21oi_1_Y_A1_sg13g2_a21oi_1_A1_Y_sg13g2_nor2_1_B_Y_sg13g2_a21oi_1_B1_Y_sg13g2_nand3_1_A/C
+ serial_opcode\[2\]_sg13g2_inv_1_A/Y serial_opcode\[3\]_sg13g2_nor2_1_B/B VSS serial_a\[7\]_sg13g2_dfrbpq_1_Q/Q
+ serial_opcode\[1\]_sg13g2_nor2b_1_A/Y sg13g2_nand4_1
Xscan_reg\[13\]_sg13g2_nor2_1_A_1 scan_reg\[13\]_sg13g2_nor2_1_A/A VDD scan_reg\[13\]_sg13g2_nor2_1_A_1/Y
+ VSS scan_reg\[41\]_sg13g2_nor2_1_A/B sg13g2_nor2_1
Xuio_out_sg13g2_nand2_1_Y_6_A_sg13g2_a22oi_1_Y uio_out_sg13g2_nand2_1_Y_6/A misr\[4\]_sg13g2_a22oi_1_B2/A2
+ VDD misr\[4\]_sg13g2_a22oi_1_B2/B1 fault_counter\[5\]_sg13g2_dfrbpq_1_Q/Q VSS misr\[5\]_sg13g2_dfrbpq_1_Q/Q
+ sg13g2_a22oi_1
Xnegative_flag_sg13g2_dfrbpq_1_Q_D_sg13g2_a21oi_1_Y_A2_sg13g2_o21ai_1_Y VSS VDD negative_flag_sg13g2_dfrbpq_1_Q_D_sg13g2_a21oi_1_Y/A2
+ negative_flag_sg13g2_dfrbpq_1_Q_D_sg13g2_a21oi_1_Y_A2_sg13g2_o21ai_1_Y/B1 negative_flag_sg13g2_dfrbpq_1_Q_D_sg13g2_a21oi_1_Y_A2_sg13g2_o21ai_1_Y/A2
+ negative_flag_sg13g2_dfrbpq_1_Q_D_sg13g2_a21oi_1_Y_A2_sg13g2_o21ai_1_Y/A1 sg13g2_o21ai_1
Xcarry_flag_sg13g2_o21ai_1_A1_B1_sg13g2_nand2_1_Y_B_sg13g2_a21oi_1_Y_A2_sg13g2_a21oi_1_Y_B1_sg13g2_o21ai_1_B1_Y_sg13g2_a221oi_1_B1_1_B2_sg13g2_xnor2_1_Y_B_sg13g2_o21ai_1_Y_A1_sg13g2_nor2_1_Y
+ serial_b\[1\]_sg13g2_xor2_1_A/A VDD carry_flag_sg13g2_o21ai_1_A1_B1_sg13g2_nand2_1_Y_B_sg13g2_a21oi_1_Y_A2_sg13g2_a21oi_1_Y_B1_sg13g2_o21ai_1_B1_Y_sg13g2_a221oi_1_B1_1_B2_sg13g2_xnor2_1_Y_B_sg13g2_o21ai_1_Y/A1
+ VSS serial_b\[1\]_sg13g2_xor2_1_A/B sg13g2_nor2_1
Xmisr\[5\]_sg13g2_dfrbpq_1_Q VDD misr\[5\]_sg13g2_dfrbpq_1_Q/D misr\[5\]_sg13g2_dfrbpq_1_Q/Q
+ clkbuf_5_7__f_clk/X VSS rst_n sg13g2_dfrbpq_1
Xserial_opcode\[1\]_sg13g2_dfrbpq_1_Q VDD serial_opcode\[1\]_sg13g2_dfrbpq_1_Q/D operation\[1\]_sg13g2_mux2_1_A0/A1
+ clkbuf_5_22__f_clk/X VSS rst_n sg13g2_dfrbpq_1
Xcarry_flag_sg13g2_o21ai_1_A1_B1_sg13g2_nand2_1_Y_A_sg13g2_nand3_1_Y_B_sg13g2_nand3_1_Y_A_sg13g2_nor3_1_A_B_sg13g2_nor2b_1_Y
+ serial_b\[6\]_sg13g2_and2_1_A/A serial_b\[6\]_sg13g2_and2_1_A/B VDD carry_flag_sg13g2_o21ai_1_A1_B1_sg13g2_nand2_1_Y_A_sg13g2_nand3_1_Y_B_sg13g2_nand3_1_Y_A_sg13g2_nor3_1_A/B
+ VSS sg13g2_nor2b_1
Xserial_b\[0\]_sg13g2_dfrbpq_1_Q_D_sg13g2_a21oi_1_Y_B1_sg13g2_nor2_1_Y serial_b\[0\]_sg13g2_xnor2_1_B/B
+ VDD serial_b\[0\]_sg13g2_dfrbpq_1_Q_D_sg13g2_a21oi_1_Y/B1 VSS ui_in[1] sg13g2_nor2_1
Xuo_out_sg13g2_dfrbpq_1_Q_6_D_sg13g2_a21oi_1_Y_A2_sg13g2_a21o_1_X_A2_sg13g2_and2_1_X_A_sg13g2_a221oi_1_Y
+ uo_out_sg13g2_dfrbpq_1_Q_6_D_sg13g2_a21oi_1_Y_A2_sg13g2_a21o_1_X_A2_sg13g2_and2_1_X_A_sg13g2_a221oi_1_Y/C1
+ uo_out_sg13g2_dfrbpq_1_Q_6_D_sg13g2_a21oi_1_Y_A2_sg13g2_a21o_1_X_A2_sg13g2_and2_1_X/A
+ uo_out_sg13g2_dfrbpq_1_Q_6_D_sg13g2_a21oi_1_Y_A2_sg13g2_a21o_1_X_A2_sg13g2_and2_1_X_A_sg13g2_a221oi_1_Y/B2
+ uo_out_sg13g2_dfrbpq_1_Q_D_sg13g2_a21oi_1_Y_B1_sg13g2_a21oi_1_Y_A1_sg13g2_nand3_1_Y_B_sg13g2_a221oi_1_Y/B2
+ uo_out_sg13g2_dfrbpq_1_Q_D_sg13g2_a21oi_1_Y_B1_sg13g2_a21oi_1_Y_A1_sg13g2_nand3_1_Y_A_sg13g2_nand2_1_Y/B
+ VDD serial_b\[4\]_sg13g2_nand2_1_A/B VSS sg13g2_a221oi_1
Xscan_reg\[53\]_sg13g2_nor2_1_A_1 scan_reg\[53\]_sg13g2_nor2_1_A/A VDD scan_reg\[53\]_sg13g2_nor2_1_A_1/Y
+ VSS scan_reg\[41\]_sg13g2_nor2_1_A/B sg13g2_nor2_1
Xoverflow_flag_sg13g2_dfrbpq_1_Q_D_sg13g2_inv_1_Y_A_sg13g2_o21ai_1_Y_B1_sg13g2_nand3_1_Y_C_sg13g2_a21oi_1_Y_A1_sg13g2_o21ai_1_A2_B1_sg13g2_o21ai_1_A1_Y_sg13g2_nor2_1_B
+ overflow_flag_sg13g2_dfrbpq_1_Q_D_sg13g2_inv_1_Y_A_sg13g2_o21ai_1_Y_B1_sg13g2_nand3_1_Y_C_sg13g2_a21oi_1_Y_A1_sg13g2_o21ai_1_A2_B1_sg13g2_o21ai_1_A1_Y_sg13g2_nor2_1_B/A
+ VDD overflow_flag_sg13g2_dfrbpq_1_Q_D_sg13g2_inv_1_Y_A_sg13g2_o21ai_1_Y_B1_sg13g2_nand3_1_Y_C_sg13g2_a21oi_1_Y_A1_sg13g2_o21ai_1_A2_B1_sg13g2_o21ai_1_A1_Y_sg13g2_nor2_1_B/Y
+ VSS overflow_flag_sg13g2_dfrbpq_1_Q_D_sg13g2_inv_1_Y_A_sg13g2_o21ai_1_Y_B1_sg13g2_nand3_1_Y_C_sg13g2_a21oi_1_Y_A1_sg13g2_o21ai_1_A2_B1_sg13g2_o21ai_1_A1/Y
+ sg13g2_nor2_1
Xbist_pattern_count\[7\]_sg13g2_dfrbpq_1_Q_D_sg13g2_a21oi_1_Y_A1_sg13g2_inv_1_Y bist_pattern_count\[6\]_sg13g2_nand3_1_C_Y_sg13g2_nor3_1_C/A
+ bist_pattern_count\[7\]_sg13g2_dfrbpq_1_Q/Q VSS VDD sg13g2_inv_1
Xserial_opcode\[3\]_sg13g2_dfrbpq_1_Q_D_sg13g2_o21ai_1_Y VSS VDD serial_opcode\[3\]_sg13g2_dfrbpq_1_Q/D
+ serial_opcode\[3\]_sg13g2_dfrbpq_1_Q_D_sg13g2_o21ai_1_Y/B1 ui_in[1] operation\[3\]_sg13g2_dfrbpq_1_Q_D_sg13g2_a21oi_1_Y/A1
+ sg13g2_o21ai_1
Xbist_pattern_count\[7\]_sg13g2_dfrbpq_1_Q_D_sg13g2_a21oi_1_Y VDD VSS bist_pattern_count\[7\]_sg13g2_dfrbpq_1_Q_D_sg13g2_a21oi_1_Y/A2
+ bist_pattern_count\[6\]_sg13g2_nand3_1_C_Y_sg13g2_nor3_1_C/A bist_fault_sg13g2_dfrbpq_1_Q_D_sg13g2_nor3_1_Y/A
+ bist_pattern_count\[7\]_sg13g2_dfrbpq_1_Q/D sg13g2_a21oi_1
Xlfsr\[4\]_sg13g2_dfrbpq_1_Q VDD lfsr\[4\]_sg13g2_dfrbpq_1_Q/D lfsr\[4\]_sg13g2_dfrbpq_1_Q/Q
+ clkbuf_5_0__f_clk/X VSS rst_n sg13g2_dfrbpq_1
Xuo_out_sg13g2_dfrbpq_1_Q_6 VDD uo_out_sg13g2_dfrbpq_1_Q_6/D uo_out[4] clkbuf_5_27__f_clk/X
+ VSS rst_n sg13g2_dfrbpq_1
Xmisr\[7\]_sg13g2_dfrbpq_1_Q_D_sg13g2_a22oi_1_Y_B2_sg13g2_o21ai_1_Y_A2_sg13g2_a22oi_1_Y_A1_sg13g2_a21oi_1_Y_A1_sg13g2_o21ai_1_Y
+ VSS VDD misr\[7\]_sg13g2_dfrbpq_1_Q_D_sg13g2_a22oi_1_Y_B2_sg13g2_o21ai_1_Y_A2_sg13g2_a22oi_1_Y_A1_sg13g2_a21oi_1_Y/A1
+ misr\[7\]_sg13g2_dfrbpq_1_Q_D_sg13g2_a22oi_1_Y_B2_sg13g2_o21ai_1_Y_A2_sg13g2_a22oi_1_Y_A1_sg13g2_a21oi_1_Y_A1_sg13g2_o21ai_1_Y/B1
+ misr\[7\]_sg13g2_dfrbpq_1_Q_D_sg13g2_a22oi_1_Y_B2_sg13g2_o21ai_1_Y_A2_sg13g2_a22oi_1_Y_A1_sg13g2_a21oi_1_Y_A1_sg13g2_o21ai_1_Y/A2
+ bist_a\[7\]_sg13g2_dfrbpq_1_Q_D_sg13g2_o21ai_1_Y_A1_sg13g2_nand2_1_A_Y_sg13g2_a221oi_1_B2_A2_sg13g2_xnor2_1_Y/A
+ sg13g2_o21ai_1
Xoperand_b\[0\]_sg13g2_mux2_1_A0 serial_b\[0\]_sg13g2_xnor2_1_B/B operand_b\[0\]_sg13g2_mux2_1_A0/X
+ ui_in[2] VDD VSS operand_b\[0\]_sg13g2_mux2_1_A0/A0 sg13g2_mux2_1
Xclkbuf_4_1_0_clk clkbuf_4_1_0_clk/X VSS clkbuf_0_clk/X VDD sg13g2_buf_4
Xscan_reg\[26\]_sg13g2_inv_1_A scan_reg\[26\]_sg13g2_inv_1_A/Y scan_reg\[26\]_sg13g2_inv_1_A/A
+ VSS VDD sg13g2_inv_1
Xscan_reg\[17\]_sg13g2_dfrbpq_1_Q VDD scan_reg\[17\]_sg13g2_dfrbpq_1_Q/D scan_reg\[17\]_sg13g2_dfrbpq_1_Q/Q
+ clkbuf_5_29__f_clk/X VSS rst_n sg13g2_dfrbpq_1
Xserial_b\[0\]_sg13g2_dfrbpq_1_Q_D_sg13g2_a21oi_1_Y VDD VSS ui_in[1] serial_b\[1\]_sg13g2_dfrbpq_1_Q_D_sg13g2_o21ai_1_Y/A1
+ serial_b\[0\]_sg13g2_dfrbpq_1_Q_D_sg13g2_a21oi_1_Y/B1 serial_b\[0\]_sg13g2_dfrbpq_1_Q/D
+ sg13g2_a21oi_1
Xlfsr\[7\]_sg13g2_xnor2_1_B_Y_sg13g2_xnor2_1_A_Y_sg13g2_a22oi_1_B2 lfsr\[7\]_sg13g2_xnor2_1_B_Y_sg13g2_xnor2_1_A_Y_sg13g2_a22oi_1_B2/Y
+ lfsr\[7\]_sg13g2_a22oi_1_A1/A2 VDD lfsr\[7\]_sg13g2_a22oi_1_A1/B1 lfsr\[1\]_sg13g2_a22oi_1_A1_B2_sg13g2_inv_1_Y/A
+ VSS lfsr\[7\]_sg13g2_xnor2_1_B_Y_sg13g2_xnor2_1_A/Y sg13g2_a22oi_1
Xcarry_flag_sg13g2_o21ai_1_A1_B1_sg13g2_nand2_1_Y_A_sg13g2_nand3_1_Y_A_sg13g2_a21oi_1_B1_Y_sg13g2_a22oi_1_B2_A1_sg13g2_nor2b_1_Y
+ serial_opcode\[2\]_sg13g2_nand2_1_A/Y serial_opcode\[1\]_sg13g2_nor2b_1_B_N/Y VDD
+ carry_flag_sg13g2_o21ai_1_A1_B1_sg13g2_nand2_1_Y_A_sg13g2_nand3_1_Y_A_sg13g2_a21oi_1_B1_Y_sg13g2_a22oi_1_B2/A1
+ VSS sg13g2_nor2b_1
Xoverflow_flag_sg13g2_dfrbpq_1_Q_D_sg13g2_inv_1_Y_A_sg13g2_o21ai_1_Y_B1_sg13g2_nand3_1_Y_A_sg13g2_and4_1_A_X_sg13g2_nand3_1_B_C_sg13g2_a22oi_1_Y_B1_sg13g2_xor2_1_X_B_sg13g2_nand2_1_Y
+ overflow_flag_sg13g2_dfrbpq_1_Q_D_sg13g2_inv_1_Y_A_sg13g2_o21ai_1_Y_B1_sg13g2_nand3_1_Y_A_sg13g2_and4_1_A_X_sg13g2_nand3_1_B_C_sg13g2_a22oi_1_Y_B1_sg13g2_xor2_1_X/B
+ VDD overflow_flag_sg13g2_dfrbpq_1_Q_D_sg13g2_inv_1_Y_A_sg13g2_o21ai_1_Y_B1_sg13g2_nand3_1_Y_A_sg13g2_nand2_1_Y_B_sg13g2_a21oi_1_Y/B1
+ VSS carry_flag_sg13g2_o21ai_1_A1_B1_sg13g2_nand2_1_Y_B_sg13g2_a21oi_1_Y_A2_sg13g2_a21oi_1_Y/A1
+ sg13g2_nand2_1
Xbist_a\[7\]_sg13g2_dfrbpq_1_Q_D_sg13g2_o21ai_1_Y_A1_sg13g2_nand2_1_A_Y_sg13g2_a221oi_1_B2_B1_sg13g2_nand2_1_Y_B_sg13g2_nor2_1_Y
+ bist_a\[7\]_sg13g2_dfrbpq_1_Q_D_sg13g2_o21ai_1_Y_A1_sg13g2_o21ai_1_A1_B1_sg13g2_a21oi_1_Y/B1
+ VDD bist_a\[7\]_sg13g2_dfrbpq_1_Q_D_sg13g2_o21ai_1_Y_A1_sg13g2_nand2_1_A_Y_sg13g2_a221oi_1_B2_B1_sg13g2_nand2_1_Y/B
+ VSS bist_a\[7\]_sg13g2_dfrbpq_1_Q_D_sg13g2_o21ai_1_Y_A1_sg13g2_o21ai_1_A1_B1_sg13g2_a21oi_1_Y/A2
+ sg13g2_nor2_1
Xcycle_counter\[2\]_sg13g2_dfrbpq_1_Q_D_sg13g2_and2_1_X_B_sg13g2_a21o_1_X cycle_counter\[2\]_sg13g2_dfrbpq_1_Q/Q
+ cycle_counter\[2\]_sg13g2_dfrbpq_1_Q_D_sg13g2_and2_1_X/B VDD VSS cycle_counter\[0\]_sg13g2_dfrbpq_1_Q/Q
+ cycle_counter\[1\]_sg13g2_dfrbpq_1_Q/Q sg13g2_a21o_1
Xscan_reg\[37\]_sg13g2_dfrbpq_1_Q VDD scan_reg\[37\]_sg13g2_dfrbpq_1_Q/D scan_reg\[37\]_sg13g2_inv_1_A/A
+ clkbuf_5_12__f_clk/X VSS rst_n sg13g2_dfrbpq_1
Xoperand_b\[4\]_sg13g2_inv_1_A operand_b\[4\]_sg13g2_inv_1_A/Y operand_b\[4\]_sg13g2_inv_1_A/A
+ VSS VDD sg13g2_inv_1
Xserial_a\[0\]_sg13g2_dfrbpq_1_Q_D_sg13g2_o21ai_1_Y_A1_sg13g2_inv_1_Y serial_a\[0\]_sg13g2_dfrbpq_1_Q_D_sg13g2_o21ai_1_Y/A1
+ serial_b\[0\]_sg13g2_xnor2_1_B/A VSS VDD sg13g2_inv_1
Xoperand_b\[7\]_sg13g2_mux2_1_A0 serial_b\[7\]_sg13g2_dfrbpq_1_Q/Q operand_b\[7\]_sg13g2_mux2_1_A0/X
+ ui_in[2] VDD VSS operand_b\[7\]_sg13g2_mux2_1_A0/A0 sg13g2_mux2_1
Xscan_reg\[57\]_sg13g2_dfrbpq_1_Q VDD scan_reg\[57\]_sg13g2_dfrbpq_1_Q/D scan_reg\[57\]_sg13g2_nor2_1_A/A
+ clkbuf_5_10__f_clk/X VSS rst_n sg13g2_dfrbpq_1
Xscan_reg\[43\]_sg13g2_nor2_1_A scan_reg\[43\]_sg13g2_nor2_1_A/A VDD scan_reg\[43\]_sg13g2_nor2_1_A/Y
+ VSS scan_reg\[3\]_sg13g2_nor2_1_A/B sg13g2_nor2_1
Xmisr\[4\]_sg13g2_dfrbpq_1_Q_D_sg13g2_a22oi_1_Y misr\[4\]_sg13g2_dfrbpq_1_Q/D misr\[7\]_sg13g2_dfrbpq_1_Q_D_sg13g2_a22oi_1_Y/A2
+ VDD bist_state\[3\]_sg13g2_nor2_1_A/Y misr\[4\]_sg13g2_inv_1_A/Y VSS misr\[4\]_sg13g2_dfrbpq_1_Q_D_sg13g2_a22oi_1_Y/B2
+ sg13g2_a22oi_1
Xscan_reg\[41\]_sg13g2_dfrbpq_1_Q_D_sg13g2_a221oi_1_Y scan_reg\[41\]_sg13g2_nor2_1_A/Y
+ scan_reg\[41\]_sg13g2_dfrbpq_1_Q/D scan_out_sg13g2_a22oi_1_A1/B1 scan_reg\[42\]_sg13g2_inv_1_A/Y
+ ui_in[3] VDD scan_reg\[41\]_sg13g2_dfrbpq_1_Q_D_sg13g2_a221oi_1_Y/A1 VSS sg13g2_a221oi_1
Xmisr\[1\]_sg13g2_inv_1_A_Y_sg13g2_xnor2_1_A_B_sg13g2_o21ai_1_Y_B1_sg13g2_nand4_1_Y_C_sg13g2_or2_1_X
+ negative_flag_sg13g2_dfrbpq_1_Q_D_sg13g2_a21oi_1_Y_A2_sg13g2_o21ai_1_Y_A2_sg13g2_o21ai_1_Y/A1
+ VSS misr\[1\]_sg13g2_dfrbpq_1_Q_D_sg13g2_a22oi_1_Y_B2_sg13g2_o21ai_1_Y_A2_sg13g2_a22oi_1_Y/A2
+ misr\[1\]_sg13g2_inv_1_A_Y_sg13g2_xnor2_1_A_B_sg13g2_o21ai_1_Y_B1_sg13g2_nand4_1_Y/C
+ VDD sg13g2_or2_1
Xbist_a\[7\]_sg13g2_dfrbpq_1_Q_D_sg13g2_o21ai_1_Y_A1_sg13g2_o21ai_1_A1_B1_sg13g2_a21oi_1_Y_B1_sg13g2_nor3_1_Y
+ bist_a\[2\]_sg13g2_dfrbpq_1_Q/Q bist_a\[7\]_sg13g2_dfrbpq_1_Q_D_sg13g2_o21ai_1_Y_A1_sg13g2_o21ai_1_A1_B1_sg13g2_a21oi_1_Y/B1
+ bist_a\[7\]_sg13g2_or2_1_A/B bist_a\[7\]_sg13g2_dfrbpq_1_Q_D_sg13g2_o21ai_1_Y_A1_sg13g2_o21ai_1_A1_B1_sg13g2_a21oi_1_Y_B1_sg13g2_nor3_1_Y/C
+ VDD VSS sg13g2_nor3_1
Xscan_reg\[12\]_sg13g2_inv_1_A scan_reg\[12\]_sg13g2_inv_1_A/Y scan_reg\[12\]_sg13g2_inv_1_A/A
+ VSS VDD sg13g2_inv_1
Xcarry_flag_sg13g2_o21ai_1_A1_B1_sg13g2_nand2_1_Y_A_sg13g2_nand3_1_Y VDD carry_flag_sg13g2_o21ai_1_A1_B1_sg13g2_nand2_1_Y/A
+ carry_flag_sg13g2_o21ai_1_A1_B1_sg13g2_nand2_1_Y_A_sg13g2_nand3_1_Y/B carry_flag_sg13g2_o21ai_1_A1_B1_sg13g2_nand2_1_Y_A_sg13g2_nand3_1_Y/C
+ carry_flag_sg13g2_o21ai_1_A1_B1_sg13g2_nand2_1_Y_A_sg13g2_nand3_1_Y/A VSS sg13g2_nand3_1
Xscan_reg\[1\]_sg13g2_o21ai_1_A1 VSS VDD scan_reg\[1\]_sg13g2_o21ai_1_A1/Y scan_reg\[1\]_sg13g2_o21ai_1_A1/B1
+ scan_reg\[3\]_sg13g2_nor2_1_A/B scan_reg\[1\]_sg13g2_dfrbpq_1_Q/Q sg13g2_o21ai_1
Xclkbuf_5_27__f_clk clkbuf_5_27__f_clk/X VSS clkbuf_4_13_0_clk/X VDD sg13g2_buf_4
Xoverflow_flag_sg13g2_dfrbpq_1_Q_D_sg13g2_inv_1_Y_A_sg13g2_o21ai_1_Y_B1_sg13g2_nand3_1_Y_A_sg13g2_nand2_1_Y_B_sg13g2_a21oi_1_Y_A2_sg13g2_nand3_1_C_Y_sg13g2_nand3_1_B_Y_sg13g2_nand4_1_B_Y_sg13g2_a221oi_1_C1
+ overflow_flag_sg13g2_dfrbpq_1_Q_D_sg13g2_inv_1_Y_A_sg13g2_o21ai_1_Y_B1_sg13g2_nand3_1_Y_A_sg13g2_nand2_1_Y_B_sg13g2_a21oi_1_Y_A2_sg13g2_nand3_1_C_Y_sg13g2_nand3_1_B_Y_sg13g2_nand4_1_B/Y
+ uo_out_sg13g2_dfrbpq_1_Q_2_D_sg13g2_o21ai_1_Y_B1_sg13g2_nand3_1_Y_B_sg13g2_nand2_1_Y/A
+ serial_b\[1\]_sg13g2_xor2_1_A/A uo_out_sg13g2_dfrbpq_1_Q_6_D_sg13g2_a21oi_1_Y_A2_sg13g2_a21o_1_X_A2_sg13g2_and2_1_X_B_sg13g2_a22oi_1_Y/A2
+ uo_out_sg13g2_dfrbpq_1_Q_D_sg13g2_a21oi_1_Y_B1_sg13g2_a21oi_1_Y_A1_sg13g2_nand3_1_Y_A_sg13g2_nand2_1_Y/B
+ VDD serial_b\[1\]_sg13g2_xor2_1_A/B VSS sg13g2_a221oi_1
Xserial_opcode\[2\]_sg13g2_nor3_1_A serial_opcode\[2\]_sg13g2_inv_1_A/A serial_opcode\[2\]_sg13g2_nor3_1_A/Y
+ serial_opcode\[3\]_sg13g2_nor2_1_B/B serial_opcode\[2\]_sg13g2_nor3_1_A/C VDD VSS
+ sg13g2_nor3_1
Xmisr\[1\]_sg13g2_inv_1_A_Y_sg13g2_xnor2_1_A_B_sg13g2_o21ai_1_Y_A2_sg13g2_nand3_1_Y_C_sg13g2_a22oi_1_Y_B1_sg13g2_and2_1_X_A_sg13g2_or3_1_X_B_sg13g2_nor2_1_Y
+ bist_a\[1\]_sg13g2_dfrbpq_1_Q/Q VDD misr\[1\]_sg13g2_inv_1_A_Y_sg13g2_xnor2_1_A_B_sg13g2_o21ai_1_Y_A2_sg13g2_nand3_1_Y_C_sg13g2_a22oi_1_Y_B1_sg13g2_and2_1_X_A_sg13g2_or3_1_X/B
+ VSS bist_a\[5\]_sg13g2_dfrbpq_1_Q/Q sg13g2_nor2_1
Xscan_reg\[30\]_sg13g2_a22oi_1_B1 scan_reg\[30\]_sg13g2_a22oi_1_B1/Y uo_out[7] VDD
+ scan_reg\[30\]_sg13g2_dfrbpq_1_Q/Q ui_in[3] VSS scan_out_sg13g2_a22oi_1_A1/A2 sg13g2_a22oi_1
Xscan_reg\[9\]_sg13g2_dfrbpq_1_Q VDD scan_reg\[9\]_sg13g2_dfrbpq_1_Q/D scan_reg\[9\]_sg13g2_inv_1_A/A
+ clkbuf_5_19__f_clk/X VSS rst_n sg13g2_dfrbpq_1
Xoperand_a\[2\]_sg13g2_inv_1_A operand_a\[2\]_sg13g2_inv_1_A/Y operand_a\[2\]_sg13g2_inv_1_A/A
+ VSS VDD sg13g2_inv_1
Xbist_a\[7\]_sg13g2_dfrbpq_1_Q_D_sg13g2_o21ai_1_Y_A1_sg13g2_nand2_1_A_Y_sg13g2_a221oi_1_B2_B1_sg13g2_nand2_1_Y_A_sg13g2_nand2_1_Y
+ bist_a\[7\]_sg13g2_dfrbpq_1_Q_D_sg13g2_o21ai_1_Y_A1_sg13g2_nand2_1_A_Y_sg13g2_a221oi_1_B2_B1_sg13g2_nand2_1_Y/A
+ VDD bist_a\[2\]_sg13g2_dfrbpq_1_Q/Q VSS bist_a\[7\]_sg13g2_dfrbpq_1_Q_D_sg13g2_o21ai_1_Y_A1_sg13g2_o21ai_1_A1_A2_sg13g2_nand3_1_Y/C
+ sg13g2_nand2_1
Xclkbuf_5_10__f_clk clkbuf_5_10__f_clk/X VSS clkbuf_4_5_0_clk/X VDD sg13g2_buf_4
Xscan_reg\[45\]_sg13g2_o21ai_1_A1_B1_sg13g2_nand2b_1_Y VSS fault_counter\[3\]_sg13g2_dfrbpq_1_Q/Q
+ scan_reg\[45\]_sg13g2_o21ai_1_A1/B1 ui_in[3] VDD sg13g2_nand2b_1
Xserial_opcode\[1\]_sg13g2_nand2_1_A serial_opcode\[2\]_sg13g2_nor3_1_A/C VDD operation\[1\]_sg13g2_mux2_1_A0/A1
+ VSS operation\[0\]_sg13g2_mux2_1_A0/A1 sg13g2_nand2_1
Xoperand_a\[2\]_sg13g2_dfrbpq_1_Q_D_sg13g2_o21ai_1_Y VSS VDD operand_a\[2\]_sg13g2_dfrbpq_1_Q/D
+ operand_a\[2\]_sg13g2_dfrbpq_1_Q_D_sg13g2_o21ai_1_Y/B1 ui_in[2] operand_a\[2\]_sg13g2_inv_1_A/Y
+ sg13g2_o21ai_1
Xmisr\[1\]_sg13g2_inv_1_A_Y_sg13g2_xnor2_1_A_B_sg13g2_o21ai_1_Y_A2_sg13g2_nand3_1_Y_C_sg13g2_a22oi_1_Y_A2_sg13g2_xnor2_1_Y_B_sg13g2_inv_1_A
+ misr\[1\]_sg13g2_inv_1_A_Y_sg13g2_xnor2_1_A_B_sg13g2_o21ai_1_Y_A2_sg13g2_nand3_1_Y_C_sg13g2_a22oi_1_Y_A2_sg13g2_xnor2_1_Y_B_sg13g2_inv_1_A/Y
+ misr\[1\]_sg13g2_inv_1_A_Y_sg13g2_xnor2_1_A_B_sg13g2_o21ai_1_Y_A2_sg13g2_nand3_1_Y_C_sg13g2_a22oi_1_Y_A2_sg13g2_xnor2_1_Y/B
+ VSS VDD sg13g2_inv_1
Xoverflow_flag_sg13g2_dfrbpq_1_Q_D_sg13g2_inv_1_Y_A_sg13g2_o21ai_1_Y_B1_sg13g2_nand3_1_Y_A_sg13g2_and4_1_A_C_sg13g2_o21ai_1_Y
+ VSS VDD overflow_flag_sg13g2_dfrbpq_1_Q_D_sg13g2_inv_1_Y_A_sg13g2_o21ai_1_Y_B1_sg13g2_nand3_1_Y_A_sg13g2_and4_1_A/C
+ overflow_flag_sg13g2_dfrbpq_1_Q_D_sg13g2_inv_1_Y_A_sg13g2_o21ai_1_Y_B1_sg13g2_nand3_1_Y_A_sg13g2_and4_1_A_C_sg13g2_o21ai_1_Y/B1
+ overflow_flag_sg13g2_dfrbpq_1_Q_D_sg13g2_inv_1_Y_A_sg13g2_o21ai_1_Y_B1_sg13g2_nand3_1_Y_A_sg13g2_and4_1_A_C_sg13g2_o21ai_1_Y/A2
+ carry_flag_sg13g2_o21ai_1_A1_B1_sg13g2_nand2_1_Y_A_sg13g2_nand3_1_Y_B_sg13g2_nand3_1_C/A
+ sg13g2_o21ai_1
Xbist_a\[7\]_sg13g2_dfrbpq_1_Q_D_sg13g2_o21ai_1_Y_A1_sg13g2_nand2_1_A bist_a\[7\]_sg13g2_dfrbpq_1_Q_D_sg13g2_o21ai_1_Y_A1_sg13g2_nand2_1_A/Y
+ VDD bist_a\[7\]_sg13g2_dfrbpq_1_Q_D_sg13g2_o21ai_1_Y/A1 VSS bist_a\[7\]_sg13g2_dfrbpq_1_Q_D_sg13g2_o21ai_1_Y_A1_sg13g2_nand2_1_A/B
+ sg13g2_nand2_1
Xbist_a\[7\]_sg13g2_dfrbpq_1_Q_D_sg13g2_o21ai_1_Y_A1_sg13g2_nand2_1_A_Y_sg13g2_a221oi_1_B2_A2_sg13g2_xnor2_1_Y_B_sg13g2_nand2_1_B
+ misr\[7\]_sg13g2_dfrbpq_1_Q_D_sg13g2_a22oi_1_Y_B2_sg13g2_o21ai_1_Y_A2_sg13g2_a22oi_1_Y_A1_sg13g2_a21oi_1_Y_A1_sg13g2_o21ai_1_Y/B1
+ VDD bist_a\[7\]_sg13g2_dfrbpq_1_Q_D_sg13g2_o21ai_1_Y_A1_sg13g2_nand2_1_A_Y_sg13g2_a221oi_1_B2_A2_sg13g2_xnor2_1_Y/A
+ VSS bist_a\[7\]_sg13g2_dfrbpq_1_Q_D_sg13g2_o21ai_1_Y_A1_sg13g2_nand2_1_A_Y_sg13g2_a221oi_1_B2_A2_sg13g2_xnor2_1_Y/B
+ sg13g2_nand2_1
Xuo_out_sg13g2_dfrbpq_1_Q_D_sg13g2_a21oi_1_Y_B1_sg13g2_a21oi_1_Y_A1_sg13g2_nand3_1_Y_B_sg13g2_a221oi_1_Y_B1_sg13g2_xnor2_1_Y_A_sg13g2_a21oi_1_Y_A1_sg13g2_inv_1_Y
+ uo_out_sg13g2_dfrbpq_1_Q_D_sg13g2_a21oi_1_Y_B1_sg13g2_a21oi_1_Y_A1_sg13g2_nand3_1_Y_B_sg13g2_a221oi_1_Y_B1_sg13g2_xnor2_1_Y_A_sg13g2_a21oi_1_Y/A1
+ serial_b\[2\]_sg13g2_xor2_1_A/X VSS VDD sg13g2_inv_1
Xuo_out_sg13g2_dfrbpq_1_Q_4_D_sg13g2_a21oi_1_Y_B1_sg13g2_nor2_1_Y uo_out[6] VDD uo_out_sg13g2_dfrbpq_1_Q_4_D_sg13g2_a21oi_1_Y/B1
+ VSS ui_in[2] sg13g2_nor2_1
Xclkbuf_5_8__f_clk clkbuf_5_8__f_clk/X VSS clkbuf_4_4_0_clk/X VDD sg13g2_buf_4
Xmisr\[4\]_sg13g2_inv_1_A_Y_sg13g2_xnor2_1_A_B_sg13g2_o21ai_1_Y_A1_sg13g2_a21oi_1_Y_A2_sg13g2_a21oi_1_Y_B1_sg13g2_o21ai_1_Y
+ VSS VDD misr\[4\]_sg13g2_inv_1_A_Y_sg13g2_xnor2_1_A_B_sg13g2_o21ai_1_Y_A1_sg13g2_a21oi_1_Y_A2_sg13g2_a21oi_1_Y/B1
+ bist_a\[7\]_sg13g2_dfrbpq_1_Q_D_sg13g2_o21ai_1_Y_A1_sg13g2_o21ai_1_A1_B1_sg13g2_nand4_1_C_Y_sg13g2_a221oi_1_C1/Y
+ misr\[4\]_sg13g2_inv_1_A_Y_sg13g2_xnor2_1_A_B_sg13g2_o21ai_1_Y_A1_sg13g2_a21oi_1_Y_A2_sg13g2_a21oi_1_Y_B1_sg13g2_o21ai_1_Y/A2
+ bist_a\[7\]_sg13g2_dfrbpq_1_Q_D_sg13g2_o21ai_1_Y_A1_sg13g2_nand2_1_A_Y_sg13g2_a221oi_1_A1_Y_sg13g2_o21ai_1_B1/A2
+ sg13g2_o21ai_1
Xbist_done_sg13g2_dfrbpq_1_Q VDD bist_done_sg13g2_dfrbpq_1_Q/D bist_done_sg13g2_inv_1_A/A
+ clkload2/A VSS rst_n sg13g2_dfrbpq_1
Xcycle_counter\[3\]_sg13g2_dfrbpq_1_Q VDD cycle_counter\[3\]_sg13g2_dfrbpq_1_Q/D cycle_counter\[3\]_sg13g2_dfrbpq_1_Q/Q
+ clkload4/A VSS rst_n sg13g2_dfrbpq_1
Xclkbuf_4_0_0_clk clkbuf_4_0_0_clk/X VSS clkbuf_0_clk/X VDD sg13g2_buf_4
Xscan_reg\[51\]_sg13g2_dfrbpq_1_Q_D_sg13g2_a21oi_1_Y VDD VSS scan_out_sg13g2_a22oi_1_A1/B1
+ scan_reg\[52\]_sg13g2_inv_1_A/Y scan_reg\[51\]_sg13g2_o21ai_1_A1/Y scan_reg\[51\]_sg13g2_dfrbpq_1_Q/D
+ sg13g2_a21oi_1
Xmisr\[7\]_sg13g2_dfrbpq_1_Q_D_sg13g2_a22oi_1_Y_B2_sg13g2_o21ai_1_Y_A2_sg13g2_a22oi_1_Y
+ misr\[7\]_sg13g2_dfrbpq_1_Q_D_sg13g2_a22oi_1_Y_B2_sg13g2_o21ai_1_Y/A2 misr\[7\]_sg13g2_dfrbpq_1_Q_D_sg13g2_a22oi_1_Y_B2_sg13g2_o21ai_1_Y_A2_sg13g2_a22oi_1_Y/A2
+ VDD misr\[7\]_sg13g2_dfrbpq_1_Q_D_sg13g2_a22oi_1_Y_B2_sg13g2_o21ai_1_Y_A2_sg13g2_a22oi_1_Y/B1
+ misr\[7\]_sg13g2_dfrbpq_1_Q_D_sg13g2_a22oi_1_Y_B2_sg13g2_o21ai_1_Y_A2_sg13g2_a22oi_1_Y/A1
+ VSS misr\[7\]_sg13g2_dfrbpq_1_Q_D_sg13g2_a22oi_1_Y_B2_sg13g2_o21ai_1_Y_A2_sg13g2_a22oi_1_Y/B2
+ sg13g2_a22oi_1
Xcarry_flag_sg13g2_o21ai_1_A1_B1_sg13g2_nand2_1_Y_A_sg13g2_nand3_1_Y_A_sg13g2_a21oi_1_B1_Y_sg13g2_a221oi_1_B2_C1_sg13g2_o21ai_1_Y_A1_sg13g2_nor2_1_Y
+ serial_a\[3\]_sg13g2_dfrbpq_1_Q/Q VDD carry_flag_sg13g2_o21ai_1_A1_B1_sg13g2_nand2_1_Y_A_sg13g2_nand3_1_Y_A_sg13g2_a21oi_1_B1_Y_sg13g2_a221oi_1_B2_C1_sg13g2_o21ai_1_Y/A1
+ VSS serial_b\[3\]_sg13g2_inv_1_A/A sg13g2_nor2_1
Xoperand_a\[1\]_sg13g2_dfrbpq_1_Q VDD operand_a\[1\]_sg13g2_mux2_1_A0/X operand_a\[1\]_sg13g2_mux2_1_A0/A0
+ clkbuf_5_4__f_clk/X VSS rst_n sg13g2_dfrbpq_1
Xscan_reg\[7\]_sg13g2_dfrbpq_1_Q_D_sg13g2_a21oi_1_Y VDD VSS scan_out_sg13g2_a22oi_1_A1/A2
+ scan_reg\[7\]_sg13g2_inv_1_A/Y scan_reg\[8\]_sg13g2_o21ai_1_A1/Y scan_reg\[7\]_sg13g2_dfrbpq_1_Q/D
+ sg13g2_a21oi_1
Xserial_opcode\[1\]_sg13g2_nand2b_1_A_N VSS operation\[1\]_sg13g2_mux2_1_A0/A1 serial_opcode\[1\]_sg13g2_nand2b_1_A_N/Y
+ operation\[0\]_sg13g2_mux2_1_A0/A1 VDD sg13g2_nand2b_1
Xoverflow_flag_sg13g2_dfrbpq_1_Q_D_sg13g2_inv_1_Y_A_sg13g2_o21ai_1_Y_B1_sg13g2_nand3_1_Y_A_sg13g2_nand2_1_Y_B_sg13g2_a21oi_1_Y_A2_sg13g2_o21ai_1_Y_B1_sg13g2_a22oi_1_B2_Y_sg13g2_nand4_1_C_D_sg13g2_a21oi_1_Y_B1_sg13g2_nor2_1_Y
+ serial_b\[6\]_sg13g2_and2_1_A/B VDD overflow_flag_sg13g2_dfrbpq_1_Q_D_sg13g2_inv_1_Y_A_sg13g2_o21ai_1_Y_B1_sg13g2_nand3_1_Y_A_sg13g2_nand2_1_Y_B_sg13g2_a21oi_1_Y_A2_sg13g2_o21ai_1_Y_B1_sg13g2_a22oi_1_B2_Y_sg13g2_nand4_1_C_D_sg13g2_a21oi_1_Y/B1
+ VSS overflow_flag_sg13g2_dfrbpq_1_Q_D_sg13g2_inv_1_Y_A_sg13g2_o21ai_1_Y_B1_sg13g2_nand3_1_Y_A_sg13g2_and4_1_A_B_sg13g2_or2_1_X/B
+ sg13g2_nor2_1
Xscan_reg\[15\]_sg13g2_o21ai_1_A1_1 VSS VDD scan_reg\[15\]_sg13g2_o21ai_1_A1_1/Y operand_b\[7\]_sg13g2_nand2b_1_A_N/Y
+ scan_reg\[41\]_sg13g2_nor2_1_A/B scan_reg\[15\]_sg13g2_dfrbpq_1_Q/Q sg13g2_o21ai_1
Xuo_out_sg13g2_dfrbpq_1_Q_D_sg13g2_a21oi_1_Y_B1_sg13g2_a21oi_1_Y_A1_sg13g2_nand3_1_Y
+ VDD uo_out_sg13g2_dfrbpq_1_Q_D_sg13g2_a21oi_1_Y_B1_sg13g2_a21oi_1_Y/A1 uo_out_sg13g2_dfrbpq_1_Q_D_sg13g2_a21oi_1_Y_B1_sg13g2_a21oi_1_Y_A1_sg13g2_nand3_1_Y/B
+ uo_out_sg13g2_dfrbpq_1_Q_D_sg13g2_a21oi_1_Y_B1_sg13g2_a21oi_1_Y_A1_sg13g2_nand3_1_Y/C
+ uo_out_sg13g2_dfrbpq_1_Q_D_sg13g2_a21oi_1_Y_B1_sg13g2_a21oi_1_Y_A1_sg13g2_nand3_1_Y/A
+ VSS sg13g2_nand3_1
Xscan_reg\[30\]_sg13g2_a22oi_1_B2 scan_reg\[30\]_sg13g2_a22oi_1_B2/Y misr\[1\]_sg13g2_a22oi_1_B2/A1
+ VDD scan_out_sg13g2_a22oi_1_A1/B1 ui_in[3] VSS scan_reg\[30\]_sg13g2_dfrbpq_1_Q/Q
+ sg13g2_a22oi_1
Xbist_fault_sg13g2_nor2_1_B_Y_sg13g2_o21ai_1_A2_Y_sg13g2_dfrbpq_1_D VDD bist_fault_sg13g2_nor2_1_B_Y_sg13g2_o21ai_1_A2/Y
+ scan_reg\[41\]_sg13g2_dfrbpq_1_Q_D_sg13g2_a221oi_1_Y/A1 clkload2/A VSS rst_n sg13g2_dfrbpq_1
Xoverflow_flag_sg13g2_dfrbpq_1_Q_D_sg13g2_inv_1_Y_A_sg13g2_o21ai_1_Y_B1_sg13g2_nand3_1_Y_A_sg13g2_and4_1_A
+ overflow_flag_sg13g2_dfrbpq_1_Q_D_sg13g2_inv_1_Y_A_sg13g2_o21ai_1_Y_B1_sg13g2_nand3_1_Y_A_sg13g2_and4_1_A/X
+ overflow_flag_sg13g2_dfrbpq_1_Q_D_sg13g2_inv_1_Y_A_sg13g2_o21ai_1_Y_B1_sg13g2_nand3_1_Y_A_sg13g2_and4_1_A/B
+ overflow_flag_sg13g2_dfrbpq_1_Q_D_sg13g2_inv_1_Y_A_sg13g2_o21ai_1_Y_B1_sg13g2_nand3_1_Y/A
+ VDD VSS overflow_flag_sg13g2_dfrbpq_1_Q_D_sg13g2_inv_1_Y_A_sg13g2_o21ai_1_Y_B1_sg13g2_nand3_1_Y_A_sg13g2_and4_1_A/C
+ overflow_flag_sg13g2_dfrbpq_1_Q_D_sg13g2_inv_1_Y_A_sg13g2_o21ai_1_Y_B1_sg13g2_nand3_1_Y_A_sg13g2_and4_1_A/D
+ sg13g2_and4_1
Xuo_out_sg13g2_dfrbpq_1_Q_6_D_sg13g2_a21oi_1_Y_A2_sg13g2_a21o_1_X_B1_sg13g2_a221oi_1_Y
+ uo_out_sg13g2_dfrbpq_1_Q_6_D_sg13g2_a21oi_1_Y_A2_sg13g2_a21o_1_X_B1_sg13g2_a221oi_1_Y/C1
+ uo_out_sg13g2_dfrbpq_1_Q_6_D_sg13g2_a21oi_1_Y_A2_sg13g2_a21o_1_X/B1 uo_out_sg13g2_dfrbpq_1_Q_5_D_sg13g2_a21oi_1_Y_A2_sg13g2_o21ai_1_Y_A2_sg13g2_mux2_1_X/A0
+ uo_out_sg13g2_dfrbpq_1_Q_6_D_sg13g2_a21oi_1_Y_A2_sg13g2_a21o_1_X/A2 uo_out_sg13g2_dfrbpq_1_Q_6_D_sg13g2_a21oi_1_Y_A2_sg13g2_a21o_1_X_B1_sg13g2_a221oi_1_Y/A2
+ VDD uio_in[1] VSS sg13g2_a221oi_1
Xuo_out_sg13g2_dfrbpq_1_Q_6_D_sg13g2_a21oi_1_Y_A2_sg13g2_a21o_1_X_A2_sg13g2_and2_1_X
+ uo_out_sg13g2_dfrbpq_1_Q_6_D_sg13g2_a21oi_1_Y_A2_sg13g2_a21o_1_X/A2 VSS VDD uo_out_sg13g2_dfrbpq_1_Q_6_D_sg13g2_a21oi_1_Y_A2_sg13g2_a21o_1_X_A2_sg13g2_and2_1_X/B
+ uo_out_sg13g2_dfrbpq_1_Q_6_D_sg13g2_a21oi_1_Y_A2_sg13g2_a21o_1_X_A2_sg13g2_and2_1_X/A
+ sg13g2_and2_1
Xoperand_a\[1\]_sg13g2_mux2_1_A0 serial_b\[1\]_sg13g2_xor2_1_A/B operand_a\[1\]_sg13g2_mux2_1_A0/X
+ ui_in[2] VDD VSS operand_a\[1\]_sg13g2_mux2_1_A0/A0 sg13g2_mux2_1
Xfault_counter\[0\]_sg13g2_dfrbpq_1_Q VDD fault_counter\[0\]_sg13g2_dfrbpq_1_Q/D fault_counter\[0\]_sg13g2_dfrbpq_1_Q/Q
+ clkbuf_5_12__f_clk/X VSS rst_n sg13g2_dfrbpq_1
Xmisr\[7\]_sg13g2_dfrbpq_1_Q_D_sg13g2_a22oi_1_Y_B2_sg13g2_o21ai_1_Y_B1_sg13g2_a21oi_1_Y
+ VDD VSS misr\[7\]_sg13g2_dfrbpq_1_Q_D_sg13g2_a22oi_1_Y_B2_sg13g2_o21ai_1_Y/A2 misr\[6\]_sg13g2_dfrbpq_1_Q/Q
+ bist_state\[1\]_sg13g2_inv_1_A/Y misr\[7\]_sg13g2_dfrbpq_1_Q_D_sg13g2_a22oi_1_Y_B2_sg13g2_o21ai_1_Y/B1
+ sg13g2_a21oi_1
Xscan_reg\[25\]_sg13g2_nor2_1_A scan_reg\[25\]_sg13g2_nor2_1_A/A VDD scan_reg\[25\]_sg13g2_nor2_1_A/Y
+ VSS scan_reg\[3\]_sg13g2_nor2_1_A/B sg13g2_nor2_1
Xzero_flag_sg13g2_dfrbpq_1_Q VDD zero_flag_sg13g2_dfrbpq_1_Q/D zero_flag_sg13g2_nand2_1_A/A
+ clkbuf_5_27__f_clk/X VSS rst_n sg13g2_dfrbpq_1
Xserial_a\[0\]_sg13g2_dfrbpq_1_Q VDD serial_a\[0\]_sg13g2_dfrbpq_1_Q/D serial_b\[0\]_sg13g2_xnor2_1_B/A
+ clkload1/A VSS rst_n sg13g2_dfrbpq_1
Xuo_out_sg13g2_dfrbpq_1_Q_3_D_sg13g2_o21ai_1_Y_B1_sg13g2_nand2_1_Y_B_sg13g2_a22oi_1_Y_A1_sg13g2_a221oi_1_Y_C1_sg13g2_or4_1_X_B_sg13g2_o21ai_1_Y
+ VSS VDD uo_out_sg13g2_dfrbpq_1_Q_3_D_sg13g2_o21ai_1_Y_B1_sg13g2_nand2_1_Y_B_sg13g2_a22oi_1_Y_A1_sg13g2_a221oi_1_Y_C1_sg13g2_or4_1_X/B
+ uo_out_sg13g2_dfrbpq_1_Q_3_D_sg13g2_o21ai_1_Y_B1_sg13g2_nand2_1_Y_B_sg13g2_a22oi_1_Y_A1_sg13g2_a221oi_1_Y_C1_sg13g2_or4_1_X_B_sg13g2_o21ai_1_Y/B1
+ uo_out_sg13g2_dfrbpq_1_Q_3_D_sg13g2_o21ai_1_Y_B1_sg13g2_nand2_1_Y_B_sg13g2_a22oi_1_Y_A1_sg13g2_a221oi_1_Y_C1_sg13g2_or4_1_X_B_sg13g2_o21ai_1_Y/A2
+ uo_out_sg13g2_dfrbpq_1_Q_3_D_sg13g2_o21ai_1_Y_B1_sg13g2_nand2_1_Y_B_sg13g2_a22oi_1_Y_A1_sg13g2_a221oi_1_Y_C1_sg13g2_or4_1_X_D_sg13g2_nor3_1_Y/B
+ sg13g2_o21ai_1
Xoperand_b\[4\]_sg13g2_dfrbpq_1_Q VDD operand_b\[4\]_sg13g2_dfrbpq_1_Q/D operand_b\[4\]_sg13g2_inv_1_A/A
+ clkbuf_5_18__f_clk/X VSS rst_n sg13g2_dfrbpq_1
Xuo_out_sg13g2_dfrbpq_1_Q_D_sg13g2_a21oi_1_Y_B1_sg13g2_a21oi_1_Y_A2_sg13g2_nand3b_1_Y_C_sg13g2_nand2b_1_Y
+ VSS uo_out_sg13g2_dfrbpq_1_Q_1_D_sg13g2_a21oi_1_Y_A2_sg13g2_o21ai_1_Y_B1_sg13g2_nand2b_1_Y/B
+ uo_out_sg13g2_dfrbpq_1_Q_D_sg13g2_a21oi_1_Y_B1_sg13g2_a21oi_1_Y_A2_sg13g2_nand3b_1_Y/C
+ uio_in[1] VDD sg13g2_nand2b_1
Xcycle_counter\[2\]_sg13g2_dfrbpq_1_Q_D_sg13g2_and2_1_X cycle_counter\[2\]_sg13g2_dfrbpq_1_Q/D
+ VSS VDD cycle_counter\[2\]_sg13g2_dfrbpq_1_Q_D_sg13g2_and2_1_X/B cycle_counter\[2\]_sg13g2_dfrbpq_1_Q_D_sg13g2_and2_1_X/A
+ sg13g2_and2_1
Xserial_b\[4\]_sg13g2_nand2_1_A serial_b\[4\]_sg13g2_nand2_1_A/Y VDD serial_b\[4\]_sg13g2_nand2_1_A/A
+ VSS serial_b\[4\]_sg13g2_nand2_1_A/B sg13g2_nand2_1
Xmisr\[4\]_sg13g2_dfrbpq_1_Q_D_sg13g2_a22oi_1_Y_B2_sg13g2_o21ai_1_Y_A2_sg13g2_a21oi_1_Y_B1_sg13g2_nor3_1_Y_C_sg13g2_nor2_1_Y
+ negative_flag_sg13g2_dfrbpq_1_Q_D_sg13g2_a21oi_1_Y_A2_sg13g2_o21ai_1_Y_A2_sg13g2_o21ai_1_Y/A1
+ VDD misr\[4\]_sg13g2_dfrbpq_1_Q_D_sg13g2_a22oi_1_Y_B2_sg13g2_o21ai_1_Y_A2_sg13g2_a21oi_1_Y_B1_sg13g2_nor3_1_Y/C
+ VSS misr\[3\]_sg13g2_dfrbpq_1_Q_D_sg13g2_o21ai_1_Y_A2_sg13g2_xnor2_1_Y_B_sg13g2_a22oi_1_Y/A2
+ sg13g2_nor2_1
Xserial_b\[0\]_sg13g2_xnor2_1_B serial_b\[0\]_sg13g2_xnor2_1_B/Y serial_b\[0\]_sg13g2_xnor2_1_B/B
+ VDD serial_b\[0\]_sg13g2_xnor2_1_B/A VSS sg13g2_xnor2_1
Xmisr\[1\]_sg13g2_inv_1_A_Y_sg13g2_xnor2_1_A_B_sg13g2_o21ai_1_Y_A2_sg13g2_nand3_1_Y_C_sg13g2_a22oi_1_Y_A2_sg13g2_xnor2_1_Y_B_sg13g2_a21oi_1_Y
+ VDD VSS misr\[1\]_sg13g2_inv_1_A_Y_sg13g2_xnor2_1_A_B_sg13g2_o21ai_1_Y_A2_sg13g2_nand3_1_Y_C_sg13g2_a22oi_1_Y_A2_sg13g2_xnor2_1_Y_B_sg13g2_a21oi_1_Y/A2
+ misr\[1\]_sg13g2_inv_1_A_Y_sg13g2_xnor2_1_A_B_sg13g2_o21ai_1_Y_A2_sg13g2_nand3_1_Y_C_sg13g2_a22oi_1_Y_A2_sg13g2_xnor2_1_Y_B_sg13g2_a21oi_1_Y/A1
+ misr\[1\]_sg13g2_inv_1_A_Y_sg13g2_xnor2_1_A_B_sg13g2_o21ai_1_Y_A2_sg13g2_nand3_1_Y_C_sg13g2_a22oi_1_Y_A2_sg13g2_xnor2_1_Y_B_sg13g2_a21oi_1_Y/B1
+ misr\[1\]_sg13g2_inv_1_A_Y_sg13g2_xnor2_1_A_B_sg13g2_o21ai_1_Y_A2_sg13g2_nand3_1_Y_C_sg13g2_a22oi_1_Y_A2_sg13g2_xnor2_1_Y/B
+ sg13g2_a21oi_1
Xscan_reg\[32\]_sg13g2_dfrbpq_1_Q_D_sg13g2_a221oi_1_Y scan_reg\[32\]_sg13g2_nor2_1_A/Y
+ scan_reg\[32\]_sg13g2_dfrbpq_1_Q/D scan_out_sg13g2_a22oi_1_A1/B1 scan_reg\[33\]_sg13g2_inv_1_A/Y
+ ui_in[3] VDD misr\[0\]_sg13g2_dfrbpq_1_Q_D_sg13g2_a22oi_1_Y/A1 VSS sg13g2_a221oi_1
Xcarry_flag_sg13g2_o21ai_1_A1_B1_sg13g2_nand2_1_Y_A_sg13g2_nand3_1_Y_B_sg13g2_nand3_1_C_Y_sg13g2_o21ai_1_B1_A2_sg13g2_nor3_1_Y
+ carry_flag_sg13g2_o21ai_1_A1_B1_sg13g2_nand2_1_Y_A_sg13g2_nand3_1_Y_B_sg13g2_nand3_1_C_A_sg13g2_o21ai_1_B1/A1
+ carry_flag_sg13g2_o21ai_1_A1_B1_sg13g2_nand2_1_Y_A_sg13g2_nand3_1_Y_B_sg13g2_nand3_1_C_Y_sg13g2_o21ai_1_B1/A2
+ carry_flag_sg13g2_o21ai_1_A1_B1_sg13g2_nand2_1_Y_A_sg13g2_nand3_1_Y_B_sg13g2_nand3_1_C_A_sg13g2_o21ai_1_B1/A2
+ carry_flag_sg13g2_o21ai_1_A1_B1_sg13g2_nand2_1_Y_A_sg13g2_nand3_1_Y_B_sg13g2_nand3_1_C_Y_sg13g2_o21ai_1_B1_A2_sg13g2_nor3_1_Y/C
+ VDD VSS sg13g2_nor3_1
Xserial_b\[2\]_sg13g2_xor2_1_A serial_b\[2\]_sg13g2_xor2_1_A/X VDD serial_b\[2\]_sg13g2_xor2_1_A/B
+ serial_b\[2\]_sg13g2_xor2_1_A/A VSS sg13g2_xor2_1
Xscan_reg\[15\]_sg13g2_o21ai_1_A1 VSS VDD scan_reg\[15\]_sg13g2_o21ai_1_A1/Y scan_reg\[15\]_sg13g2_o21ai_1_A1/B1
+ scan_reg\[3\]_sg13g2_nor2_1_A/B scan_reg\[15\]_sg13g2_dfrbpq_1_Q/Q sg13g2_o21ai_1
Xbist_a\[7\]_sg13g2_dfrbpq_1_Q_D_sg13g2_o21ai_1_Y_A1_sg13g2_nand2_1_A_Y_sg13g2_a221oi_1_B2_A2_sg13g2_xnor2_1_Y_A_sg13g2_and2_1_X
+ bist_a\[7\]_sg13g2_dfrbpq_1_Q_D_sg13g2_o21ai_1_Y_A1_sg13g2_nand2_1_A_Y_sg13g2_a221oi_1_B2_A2_sg13g2_xnor2_1_Y/A
+ VSS VDD bist_a\[7\]_sg13g2_dfrbpq_1_Q_D_sg13g2_o21ai_1_Y_A1_sg13g2_nand2_1_A_Y_sg13g2_a221oi_1_B2_A2_sg13g2_xnor2_1_Y_A_sg13g2_and2_1_X/B
+ bist_a\[7\]_sg13g2_or2_1_A/X sg13g2_and2_1
Xoperation\[0\]_sg13g2_nand2b_1_A_N VSS operation\[0\]_sg13g2_mux2_1_A0/A0 scan_reg\[17\]_sg13g2_o21ai_1_A1/B1
+ ui_in[3] VDD sg13g2_nand2b_1
Xbist_a\[7\]_sg13g2_dfrbpq_1_Q_D_sg13g2_o21ai_1_Y_A1_sg13g2_nand2_1_A_Y_sg13g2_a221oi_1_B2_Y_sg13g2_o21ai_1_B1_A1_sg13g2_nor3_1_Y
+ bist_a\[7\]_sg13g2_dfrbpq_1_Q_D_sg13g2_o21ai_1_Y_A1_sg13g2_nand2_1_A_Y_sg13g2_a221oi_1_B2_Y_sg13g2_o21ai_1_B1_A1_sg13g2_nor3_1_Y/A
+ bist_a\[7\]_sg13g2_dfrbpq_1_Q_D_sg13g2_o21ai_1_Y_A1_sg13g2_nand2_1_A_Y_sg13g2_a221oi_1_B2_Y_sg13g2_o21ai_1_B1/A1
+ bist_a\[7\]_sg13g2_dfrbpq_1_Q_D_sg13g2_o21ai_1_Y_A1_sg13g2_nand2_1_A_Y_sg13g2_a221oi_1_B2_Y_sg13g2_o21ai_1_B1_A1_sg13g2_nor3_1_Y/B
+ bist_a\[7\]_sg13g2_dfrbpq_1_Q_D_sg13g2_o21ai_1_Y_A1_sg13g2_nand2_1_A_Y_sg13g2_a221oi_1_B2_Y_sg13g2_o21ai_1_B1_A1_sg13g2_nor3_1_Y/C
+ VDD VSS sg13g2_nor3_1
Xscan_reg\[55\]_sg13g2_o21ai_1_A1 VSS VDD scan_reg\[55\]_sg13g2_o21ai_1_A1/Y scan_reg\[55\]_sg13g2_o21ai_1_A1/B1
+ scan_reg\[41\]_sg13g2_nor2_1_A/B scan_reg\[55\]_sg13g2_nor2_1_A/A sg13g2_o21ai_1
Xuo_out_sg13g2_dfrbpq_1_Q_5_D_sg13g2_a21oi_1_Y_A2_sg13g2_o21ai_1_Y_B1_sg13g2_or2_1_X_B_sg13g2_nand2_1_Y_A_sg13g2_a221oi_1_Y_C1_sg13g2_nand4_1_Y_B_sg13g2_o21ai_1_Y_B1_sg13g2_a21o_1_X
+ serial_opcode\[2\]_sg13g2_nor3_1_A/Y uo_out_sg13g2_dfrbpq_1_Q_5_D_sg13g2_a21oi_1_Y_A2_sg13g2_o21ai_1_Y_B1_sg13g2_or2_1_X_B_sg13g2_nand2_1_Y_A_sg13g2_a221oi_1_Y_C1_sg13g2_nand4_1_Y_B_sg13g2_o21ai_1_Y/B1
+ VDD VSS uo_out_sg13g2_dfrbpq_1_Q_5_D_sg13g2_a21oi_1_Y_A2_sg13g2_o21ai_1_Y_B1_sg13g2_or2_1_X_B_sg13g2_nand2_1_Y_A_sg13g2_a221oi_1_Y_C1_sg13g2_nand4_1_Y_B_sg13g2_o21ai_1_Y_B1_sg13g2_a21o_1_X/A1
+ uo_out_sg13g2_dfrbpq_1_Q_6_D_sg13g2_a21oi_1_Y_A2_sg13g2_a21o_1_X_A2_sg13g2_and2_1_X_A_sg13g2_a221oi_1_Y_C1_sg13g2_nand3_1_Y_C_sg13g2_a221oi_1_Y/A2
+ sg13g2_a21o_1
Xserial_b\[3\]_sg13g2_dfrbpq_1_Q VDD serial_b\[3\]_sg13g2_dfrbpq_1_Q/D serial_b\[3\]_sg13g2_inv_1_A/A
+ clkbuf_5_16__f_clk/X VSS rst_n sg13g2_dfrbpq_1
Xuio_out_sg13g2_nand2_1_Y_6_B_sg13g2_a22oi_1_Y_B2_sg13g2_inv_1_Y uio_out_sg13g2_nand2_1_Y_6_B_sg13g2_a22oi_1_Y/B2
+ scan_reg\[41\]_sg13g2_dfrbpq_1_Q_D_sg13g2_a221oi_1_Y/A1 VSS VDD sg13g2_inv_1
Xserial_opcode\[1\]_sg13g2_nor2b_1_A operation\[1\]_sg13g2_mux2_1_A0/A1 operation\[0\]_sg13g2_mux2_1_A0/A1
+ VDD serial_opcode\[1\]_sg13g2_nor2b_1_A/Y VSS sg13g2_nor2b_1
Xcycle_counter\[3\]_sg13g2_dfrbpq_1_Q_D_sg13g2_xnor2_1_Y cycle_counter\[3\]_sg13g2_dfrbpq_1_Q/D
+ cycle_counter\[2\]_sg13g2_dfrbpq_1_Q_D_sg13g2_and2_1_X/A VDD cycle_counter\[3\]_sg13g2_dfrbpq_1_Q/Q
+ VSS sg13g2_xnor2_1
Xuo_out_sg13g2_dfrbpq_1_Q_5_D_sg13g2_a21oi_1_Y_A2_sg13g2_o21ai_1_Y_A1_sg13g2_o21ai_1_Y
+ VSS VDD uo_out_sg13g2_dfrbpq_1_Q_5_D_sg13g2_a21oi_1_Y_A2_sg13g2_o21ai_1_Y/A1 uo_out_sg13g2_dfrbpq_1_Q_4_D_sg13g2_a21oi_1_Y_A2_sg13g2_a21o_1_X_A2_sg13g2_a21o_1_X/A1
+ uo_out_sg13g2_dfrbpq_1_Q_6_D_sg13g2_a21oi_1_Y_A2_sg13g2_a21o_1_X/A2 misr\[4\]_sg13g2_inv_1_A_Y_sg13g2_xnor2_1_A_B_sg13g2_o21ai_1_Y_A1_sg13g2_a21oi_1_Y/B1
+ sg13g2_o21ai_1
Xscan_reg\[9\]_sg13g2_dfrbpq_1_Q_D_sg13g2_a221oi_1_Y scan_reg\[10\]_sg13g2_nor2_1_A/Y
+ scan_reg\[9\]_sg13g2_dfrbpq_1_Q/D scan_out_sg13g2_a22oi_1_A1/A2 scan_reg\[9\]_sg13g2_inv_1_A/Y
+ operand_b\[1\]_sg13g2_inv_1_A/Y VDD ui_in[3] VSS sg13g2_a221oi_1
Xoperand_b\[4\]_sg13g2_dfrbpq_1_Q_D_sg13g2_o21ai_1_Y VSS VDD operand_b\[4\]_sg13g2_dfrbpq_1_Q/D
+ operand_b\[4\]_sg13g2_dfrbpq_1_Q_D_sg13g2_o21ai_1_Y/B1 ui_in[2] operand_b\[4\]_sg13g2_inv_1_A/Y
+ sg13g2_o21ai_1
Xbist_a\[7\]_sg13g2_dfrbpq_1_Q_D_sg13g2_o21ai_1_Y_A1_sg13g2_nand2_1_A_B_sg13g2_o21ai_1_A2_B1_sg13g2_a21oi_1_Y
+ VDD VSS bist_a\[7\]_sg13g2_dfrbpq_1_Q_D_sg13g2_o21ai_1_Y_A1_sg13g2_nand2_1_A_B_sg13g2_o21ai_1_A2_B1_sg13g2_a21oi_1_Y/A2
+ bist_a\[5\]_sg13g2_dfrbpq_1_Q/Q bist_a\[7\]_sg13g2_dfrbpq_1_Q_D_sg13g2_o21ai_1_Y_A1_sg13g2_o21ai_1_A1_B1_sg13g2_a21oi_1_Y/B1
+ bist_a\[7\]_sg13g2_dfrbpq_1_Q_D_sg13g2_o21ai_1_Y_A1_sg13g2_nand2_1_A_B_sg13g2_o21ai_1_A2/B1
+ sg13g2_a21oi_1
Xmisr\[4\]_sg13g2_inv_1_A_Y_sg13g2_xnor2_1_A_B_sg13g2_o21ai_1_Y_B1_sg13g2_or2_1_X_A_sg13g2_nand3_1_Y_C_sg13g2_a21oi_1_Y
+ VDD VSS misr\[4\]_sg13g2_inv_1_A_Y_sg13g2_xnor2_1_A_B_sg13g2_o21ai_1_Y_B1_sg13g2_or2_1_X_A_sg13g2_nand3_1_Y_C_sg13g2_a21oi_1_Y/A2
+ bist_a\[7\]_sg13g2_dfrbpq_1_Q_D_sg13g2_o21ai_1_Y_A1_sg13g2_nand2_1_A_Y_sg13g2_a221oi_1_B2/A1
+ misr\[4\]_sg13g2_inv_1_A_Y_sg13g2_xnor2_1_A_B_sg13g2_o21ai_1_Y_B1_sg13g2_or2_1_X_A_sg13g2_nand3_1_Y_C_sg13g2_a21oi_1_Y/B1
+ misr\[4\]_sg13g2_inv_1_A_Y_sg13g2_xnor2_1_A_B_sg13g2_o21ai_1_Y_B1_sg13g2_or2_1_X_A_sg13g2_nand3_1_Y/C
+ sg13g2_a21oi_1
Xbist_a\[7\]_sg13g2_dfrbpq_1_Q_D_sg13g2_o21ai_1_Y_A1_sg13g2_nand2_1_A_Y_sg13g2_a221oi_1_B2_C1_sg13g2_or2_1_X
+ bist_a\[7\]_sg13g2_dfrbpq_1_Q_D_sg13g2_o21ai_1_Y_A1_sg13g2_nand2_1_A_Y_sg13g2_a221oi_1_B2_C1_sg13g2_or2_1_X/A
+ VSS misr\[4\]_sg13g2_inv_1_A_Y_sg13g2_xnor2_1_A_B_sg13g2_o21ai_1_Y_A1_sg13g2_a21oi_1_Y_A2_sg13g2_a21oi_1_Y/A1
+ bist_a\[7\]_sg13g2_dfrbpq_1_Q_D_sg13g2_o21ai_1_Y_A1_sg13g2_nand2_1_A_Y_sg13g2_a221oi_1_B2/C1
+ VDD sg13g2_or2_1
Xclkbuf_5_16__f_clk clkbuf_5_16__f_clk/X VSS clkbuf_4_8_0_clk/X VDD sg13g2_buf_4
Xbist_a\[7\]_sg13g2_dfrbpq_1_Q_D_sg13g2_o21ai_1_Y_A1_sg13g2_nand2_1_A_B_sg13g2_inv_1_Y_A_sg13g2_nor2_1_Y_B_sg13g2_nand2_1_Y
+ bist_a\[7\]_sg13g2_dfrbpq_1_Q_D_sg13g2_o21ai_1_Y_A1_sg13g2_nand2_1_A_B_sg13g2_inv_1_Y_A_sg13g2_nor2_1_Y/B
+ VDD bist_a\[0\]_sg13g2_dfrbpq_1_Q/Q VSS bist_a\[7\]_sg13g2_dfrbpq_1_Q_D_sg13g2_o21ai_1_Y_A1_sg13g2_o21ai_1_A1_B1_sg13g2_a21oi_1_Y_A2_sg13g2_and2_1_X/A
+ sg13g2_nand2_1
Xscan_reg\[36\]_sg13g2_a22oi_1_B1 scan_reg\[36\]_sg13g2_a22oi_1_B1/Y ui_in[3] VDD
+ scan_reg\[36\]_sg13g2_inv_1_A/A misr\[3\]_sg13g2_dfrbpq_1_Q/Q VSS scan_out_sg13g2_a22oi_1_A1/B1
+ sg13g2_a22oi_1
Xmisr\[0\]_sg13g2_dfrbpq_1_Q VDD misr\[0\]_sg13g2_dfrbpq_1_Q/D misr\[0\]_sg13g2_dfrbpq_1_Q/Q
+ clkbuf_5_13__f_clk/X VSS rst_n sg13g2_dfrbpq_1
Xscan_reg\[8\]_sg13g2_dfrbpq_1_Q_D_sg13g2_a21oi_1_Y VDD VSS scan_out_sg13g2_a22oi_1_A1/B1
+ scan_reg\[9\]_sg13g2_inv_1_A/Y scan_reg\[8\]_sg13g2_o21ai_1_A1_1/Y scan_reg\[8\]_sg13g2_dfrbpq_1_Q/D
+ sg13g2_a21oi_1
Xmisr\[1\]_sg13g2_inv_1_A_Y_sg13g2_xnor2_1_A_B_sg13g2_o21ai_1_Y VSS VDD misr\[1\]_sg13g2_inv_1_A_Y_sg13g2_xnor2_1_A/B
+ misr\[1\]_sg13g2_inv_1_A_Y_sg13g2_xnor2_1_A_B_sg13g2_o21ai_1_Y/B1 misr\[1\]_sg13g2_inv_1_A_Y_sg13g2_xnor2_1_A_B_sg13g2_o21ai_1_Y/A2
+ misr\[1\]_sg13g2_inv_1_A_Y_sg13g2_xnor2_1_A_B_sg13g2_o21ai_1_Y/A1 sg13g2_o21ai_1
Xcarry_flag_sg13g2_o21ai_1_A1_B1_sg13g2_nand2_1_Y_B_sg13g2_a21oi_1_Y_A2_sg13g2_a21oi_1_Y_B1_sg13g2_o21ai_1_B1_Y_sg13g2_a221oi_1_B1_1_B2_sg13g2_xnor2_1_Y_B_sg13g2_o21ai_1_Y
+ VSS VDD carry_flag_sg13g2_o21ai_1_A1_B1_sg13g2_nand2_1_Y_B_sg13g2_a21oi_1_Y_A2_sg13g2_a21oi_1_Y_B1_sg13g2_o21ai_1_B1_Y_sg13g2_a221oi_1_B1_1_B2_sg13g2_xnor2_1_Y/B
+ carry_flag_sg13g2_o21ai_1_A1_B1_sg13g2_nand2_1_Y_B_sg13g2_a21oi_1_Y_A2_sg13g2_a21oi_1_Y_B1_sg13g2_o21ai_1_B1_Y_sg13g2_a221oi_1_B1_1_B2_sg13g2_xnor2_1_Y_B_sg13g2_o21ai_1_Y/B1
+ operation\[3\]_sg13g2_dfrbpq_1_Q_D_sg13g2_a21oi_1_Y_A1_sg13g2_a21oi_1_A1_Y_sg13g2_nor2_1_B_Y_sg13g2_a21oi_1_B1_Y_sg13g2_nand3_1_A_B_sg13g2_nand2b_1_Y/A_N
+ carry_flag_sg13g2_o21ai_1_A1_B1_sg13g2_nand2_1_Y_B_sg13g2_a21oi_1_Y_A2_sg13g2_a21oi_1_Y_B1_sg13g2_o21ai_1_B1_Y_sg13g2_a221oi_1_B1_1_B2_sg13g2_xnor2_1_Y_B_sg13g2_o21ai_1_Y/A1
+ sg13g2_o21ai_1
Xscan_reg\[26\]_sg13g2_dfrbpq_1_Q_D_sg13g2_a221oi_1_Y scan_reg\[27\]_sg13g2_nor2_1_A/Y
+ scan_reg\[26\]_sg13g2_dfrbpq_1_Q/D scan_out_sg13g2_a22oi_1_A1/A2 scan_reg\[26\]_sg13g2_inv_1_A/Y
+ scan_reg\[26\]_sg13g2_dfrbpq_1_Q_D_sg13g2_a221oi_1_Y/A2 VDD ui_in[3] VSS sg13g2_a221oi_1
Xoperation\[2\]_sg13g2_dfrbpq_1_Q VDD operation\[2\]_sg13g2_dfrbpq_1_Q/D operation\[2\]_sg13g2_inv_1_A/A
+ clkbuf_5_28__f_clk/X VSS rst_n sg13g2_dfrbpq_1
Xuio_out_sg13g2_nand2_1_Y_1_B_sg13g2_a22oi_1_Y uio_out_sg13g2_nand2_1_Y_1/B misr\[1\]_sg13g2_a22oi_1_B2/A2
+ VDD misr\[4\]_sg13g2_a22oi_1_B2/A2 overflow_flag_sg13g2_dfrbpq_1_Q/Q VSS fault_counter\[3\]_sg13g2_dfrbpq_1_Q/Q
+ sg13g2_a22oi_1
Xuo_out_sg13g2_dfrbpq_1_Q_D_sg13g2_a21oi_1_Y_B1_sg13g2_a21oi_1_Y_A1_sg13g2_nand3_1_Y_B_sg13g2_a221oi_1_Y_C1_sg13g2_o21ai_1_Y_A2_sg13g2_xnor2_1_Y
+ uo_out_sg13g2_dfrbpq_1_Q_D_sg13g2_a21oi_1_Y_B1_sg13g2_a21oi_1_Y_A1_sg13g2_nand3_1_Y_B_sg13g2_a221oi_1_Y_C1_sg13g2_o21ai_1_Y/A2
+ uo_out_sg13g2_dfrbpq_1_Q_D_sg13g2_a21oi_1_Y_B1_sg13g2_a21oi_1_Y_A1_sg13g2_nand3_1_Y_B_sg13g2_a221oi_1_Y_C1_sg13g2_o21ai_1_Y_A2_sg13g2_xnor2_1_Y/B
+ VDD uo_out_sg13g2_dfrbpq_1_Q_D_sg13g2_a21oi_1_Y_B1_sg13g2_a21oi_1_Y_A1_sg13g2_nand3_1_Y_B_sg13g2_a221oi_1_Y_B1_sg13g2_xnor2_1_Y/B
+ VSS sg13g2_xnor2_1
Xbist_fault_sg13g2_nor2_1_B_Y_sg13g2_o21ai_1_A2_B1_sg13g2_nand3b_1_Y_B_sg13g2_nand2_1_Y
+ bist_fault_sg13g2_nor2_1_B_Y_sg13g2_o21ai_1_A2_B1_sg13g2_nand3b_1_Y/B VDD bist_fault_sg13g2_o21ai_1_A2/B1
+ VSS bist_state\[1\]_sg13g2_a21oi_1_A1/A2 sg13g2_nand2_1
Xuo_out_sg13g2_dfrbpq_1_Q_5_D_sg13g2_a21oi_1_Y_A2_sg13g2_o21ai_1_Y_B1_sg13g2_or2_1_X
+ misr\[4\]_sg13g2_inv_1_A_Y_sg13g2_xnor2_1_A_B_sg13g2_o21ai_1_Y_B1_sg13g2_or2_1_X/B
+ VSS uo_out_sg13g2_dfrbpq_1_Q_5_D_sg13g2_a21oi_1_Y_A2_sg13g2_o21ai_1_Y_B1_sg13g2_or2_1_X/B
+ uo_out_sg13g2_dfrbpq_1_Q_5_D_sg13g2_a21oi_1_Y_A2_sg13g2_o21ai_1_Y/B1 VDD sg13g2_or2_1
Xscan_reg\[51\]_sg13g2_nor2_1_A scan_reg\[51\]_sg13g2_nor2_1_A/A VDD scan_reg\[51\]_sg13g2_nor2_1_A/Y
+ VSS scan_reg\[3\]_sg13g2_nor2_1_A/B sg13g2_nor2_1
Xuo_out_sg13g2_dfrbpq_1_Q_5_D_sg13g2_a21oi_1_Y VDD VSS uo_out_sg13g2_dfrbpq_1_Q_5_D_sg13g2_a21oi_1_Y/A2
+ ui_in[2] uo_out_sg13g2_dfrbpq_1_Q_5_D_sg13g2_a21oi_1_Y/B1 uo_out_sg13g2_dfrbpq_1_Q_5/D
+ sg13g2_a21oi_1
Xbist_done_sg13g2_dfrbpq_1_Q_D_sg13g2_o21ai_1_Y_B1_sg13g2_o21ai_1_Y VSS VDD bist_fault_sg13g2_nor2_1_B_Y_sg13g2_o21ai_1_A2/A1
+ bist_fault_sg13g2_o21ai_1_A2/B1 bist_state\[1\]_sg13g2_a21oi_1_A1/A2 ui_in[7] sg13g2_o21ai_1
Xscan_reg\[12\]_sg13g2_dfrbpq_1_Q VDD scan_reg\[12\]_sg13g2_dfrbpq_1_Q/D scan_reg\[12\]_sg13g2_inv_1_A/A
+ clkbuf_5_18__f_clk/X VSS rst_n sg13g2_dfrbpq_1
Xoperand_b\[6\]_sg13g2_nand2b_1_A_N VSS operand_b\[6\]_sg13g2_mux2_1_A0/A0 scan_reg\[15\]_sg13g2_o21ai_1_A1/B1
+ ui_in[3] VDD sg13g2_nand2b_1
Xmisr\[4\]_sg13g2_a22oi_1_B2 uio_out_sg13g2_nand2_1_Y_7/B misr\[4\]_sg13g2_a22oi_1_B2/A2
+ VDD misr\[4\]_sg13g2_a22oi_1_B2/B1 misr\[4\]_sg13g2_a22oi_1_B2/A1 VSS misr\[4\]_sg13g2_inv_1_A/A
+ sg13g2_a22oi_1
Xnegative_flag_sg13g2_dfrbpq_1_Q_D_sg13g2_a21oi_1_Y_A2_sg13g2_o21ai_1_Y_A2_sg13g2_o21ai_1_Y_B1_sg13g2_mux2_1_X
+ misr\[7\]_sg13g2_dfrbpq_1_Q_D_sg13g2_a22oi_1_Y_B2_sg13g2_o21ai_1_Y_A2_sg13g2_a22oi_1_Y_B1_sg13g2_mux2_1_X/A0
+ negative_flag_sg13g2_dfrbpq_1_Q_D_sg13g2_a21oi_1_Y_A2_sg13g2_o21ai_1_Y_A2_sg13g2_o21ai_1_Y/B1
+ negative_flag_sg13g2_dfrbpq_1_Q_D_sg13g2_a21oi_1_Y_A2_sg13g2_o21ai_1_Y_B1_sg13g2_nand2b_1_Y/A_N
+ VDD VSS misr\[4\]_sg13g2_inv_1_A_Y_sg13g2_xnor2_1_A_B_sg13g2_o21ai_1_Y_A2_sg13g2_o21ai_1_Y/A1
+ sg13g2_mux2_1
Xoperand_a\[2\]_sg13g2_dfrbpq_1_Q_D_sg13g2_o21ai_1_Y_B1_sg13g2_nand2_1_Y operand_a\[2\]_sg13g2_dfrbpq_1_Q_D_sg13g2_o21ai_1_Y/B1
+ VDD serial_b\[2\]_sg13g2_xor2_1_A/B VSS ui_in[2] sg13g2_nand2_1
Xscan_reg\[32\]_sg13g2_dfrbpq_1_Q VDD scan_reg\[32\]_sg13g2_dfrbpq_1_Q/D scan_reg\[32\]_sg13g2_nor2_1_A/A
+ clkbuf_5_24__f_clk/X VSS rst_n sg13g2_dfrbpq_1
Xmisr\[7\]_sg13g2_dfrbpq_1_Q_D_sg13g2_a22oi_1_Y_B2_sg13g2_o21ai_1_Y_A2_sg13g2_a22oi_1_Y_A2_sg13g2_nand2_1_Y
+ misr\[7\]_sg13g2_dfrbpq_1_Q_D_sg13g2_a22oi_1_Y_B2_sg13g2_o21ai_1_Y_A2_sg13g2_a22oi_1_Y/A2
+ VDD uio_in[0] VSS misr\[7\]_sg13g2_dfrbpq_1_Q_D_sg13g2_a22oi_1_Y_B2_sg13g2_o21ai_1_Y_A2_sg13g2_a22oi_1_Y_B1_sg13g2_mux2_1_X/A0
+ sg13g2_nand2_1
Xuo_out_sg13g2_dfrbpq_1_Q_5_D_sg13g2_a21oi_1_Y_A2_sg13g2_o21ai_1_Y VSS VDD uo_out_sg13g2_dfrbpq_1_Q_5_D_sg13g2_a21oi_1_Y/A2
+ uo_out_sg13g2_dfrbpq_1_Q_5_D_sg13g2_a21oi_1_Y_A2_sg13g2_o21ai_1_Y/B1 uo_out_sg13g2_dfrbpq_1_Q_5_D_sg13g2_a21oi_1_Y_A2_sg13g2_o21ai_1_Y/A2
+ uo_out_sg13g2_dfrbpq_1_Q_5_D_sg13g2_a21oi_1_Y_A2_sg13g2_o21ai_1_Y/A1 sg13g2_o21ai_1
Xuo_out_sg13g2_dfrbpq_1_Q_6_D_sg13g2_a21oi_1_Y_A2_sg13g2_a21o_1_X_A1_sg13g2_or3_1_X_C_sg13g2_nand2_1_Y
+ uo_out_sg13g2_dfrbpq_1_Q_6_D_sg13g2_a21oi_1_Y_A2_sg13g2_a21o_1_X_A1_sg13g2_or3_1_X/C
+ VDD uio_in[0] VSS uio_in[5] sg13g2_nand2_1
Xserial_opcode\[0\]_sg13g2_dfrbpq_1_Q_D_sg13g2_mux2_1_X operation\[1\]_sg13g2_mux2_1_A0/A1
+ serial_opcode\[0\]_sg13g2_dfrbpq_1_Q/D ui_in[1] VDD VSS operation\[0\]_sg13g2_mux2_1_A0/A1
+ sg13g2_mux2_1
Xscan_reg\[52\]_sg13g2_dfrbpq_1_Q VDD scan_reg\[52\]_sg13g2_dfrbpq_1_Q/D scan_reg\[52\]_sg13g2_inv_1_A/A
+ clkload4/A VSS rst_n sg13g2_dfrbpq_1
Xbist_a\[7\]_sg13g2_dfrbpq_1_Q_D_sg13g2_o21ai_1_Y_A1_sg13g2_o21ai_1_A1_B1_sg13g2_a21oi_1_Y_A2_sg13g2_and2_1_X
+ bist_a\[7\]_sg13g2_dfrbpq_1_Q_D_sg13g2_o21ai_1_Y_A1_sg13g2_o21ai_1_A1_B1_sg13g2_a21oi_1_Y/A2
+ VSS VDD bist_a\[7\]_sg13g2_dfrbpq_1_Q_D_sg13g2_o21ai_1_Y_A1_sg13g2_o21ai_1_A1_B1_sg13g2_a21oi_1_Y_A2_sg13g2_and2_1_X/B
+ bist_a\[7\]_sg13g2_dfrbpq_1_Q_D_sg13g2_o21ai_1_Y_A1_sg13g2_o21ai_1_A1_B1_sg13g2_a21oi_1_Y_A2_sg13g2_and2_1_X/A
+ sg13g2_and2_1
Xuo_out_sg13g2_dfrbpq_1_Q_D_sg13g2_a21oi_1_Y_B1_sg13g2_a21oi_1_Y_A1_sg13g2_nand3_1_Y_B_sg13g2_a221oi_1_Y_B1_sg13g2_xnor2_1_Y_A_sg13g2_a21oi_1_Y_A2_sg13g2_o21ai_1_Y_B1_sg13g2_nand2b_1_Y
+ VSS serial_b\[1\]_sg13g2_xor2_1_A/A uo_out_sg13g2_dfrbpq_1_Q_D_sg13g2_a21oi_1_Y_B1_sg13g2_a21oi_1_Y_A1_sg13g2_nand3_1_Y_B_sg13g2_a221oi_1_Y_B1_sg13g2_xnor2_1_Y_A_sg13g2_a21oi_1_Y_A2_sg13g2_o21ai_1_Y/B1
+ serial_b\[1\]_sg13g2_xor2_1_A/B VDD sg13g2_nand2b_1
Xbist_state\[3\]_sg13g2_nor2_1_A bist_fault_sg13g2_o21ai_1_A2/B1 VDD bist_state\[3\]_sg13g2_nor2_1_A/Y
+ VSS lfsr\[7\]_sg13g2_a22oi_1_A1/A2 sg13g2_nor2_1
Xoperand_a\[7\]_sg13g2_dfrbpq_1_Q VDD operand_a\[7\]_sg13g2_mux2_1_A0/X operand_a\[7\]_sg13g2_mux2_1_A0/A0
+ clkbuf_5_22__f_clk/X VSS rst_n sg13g2_dfrbpq_1
Xfault_counter\[0\]_sg13g2_dfrbpq_1_Q_D_sg13g2_xnor2_1_Y fault_counter\[0\]_sg13g2_dfrbpq_1_Q/D
+ bist_fault_sg13g2_o21ai_1_A2/Y VDD fault_counter\[0\]_sg13g2_dfrbpq_1_Q/Q VSS sg13g2_xnor2_1
Xserial_a\[7\]_sg13g2_dfrbpq_1_Q_D_sg13g2_mux2_1_X serial_b\[0\]_sg13g2_xnor2_1_B/B
+ serial_a\[7\]_sg13g2_dfrbpq_1_Q/D ui_in[1] VDD VSS serial_a\[7\]_sg13g2_dfrbpq_1_Q/Q
+ sg13g2_mux2_1
Xmisr\[1\]_sg13g2_inv_1_A_Y_sg13g2_xnor2_1_A_B_sg13g2_o21ai_1_Y_A2_sg13g2_nand3_1_Y_C_sg13g2_a22oi_1_Y_B1_sg13g2_and2_1_X_A_sg13g2_or3_1_X
+ VDD VSS misr\[1\]_sg13g2_inv_1_A_Y_sg13g2_xnor2_1_A_B_sg13g2_o21ai_1_Y_A2_sg13g2_nand3_1_Y_C_sg13g2_a22oi_1_Y_B1_sg13g2_and2_1_X_A_sg13g2_or3_1_X/C
+ misr\[1\]_sg13g2_inv_1_A_Y_sg13g2_xnor2_1_A_B_sg13g2_o21ai_1_Y_A2_sg13g2_nand3_1_Y_C_sg13g2_a22oi_1_Y_B1_sg13g2_and2_1_X_A_sg13g2_or3_1_X/B
+ misr\[1\]_sg13g2_inv_1_A_Y_sg13g2_xnor2_1_A_B_sg13g2_o21ai_1_Y_A2_sg13g2_nand3_1_Y_C_sg13g2_a22oi_1_Y_B1_sg13g2_and2_1_X_A_sg13g2_or3_1_X/A
+ misr\[1\]_sg13g2_inv_1_A_Y_sg13g2_xnor2_1_A_B_sg13g2_o21ai_1_Y_A2_sg13g2_nand3_1_Y_C_sg13g2_a22oi_1_Y_B1_sg13g2_and2_1_X/A
+ sg13g2_or3_1
Xuo_out_sg13g2_dfrbpq_1_Q_3_D_sg13g2_o21ai_1_Y_B1_sg13g2_nand2_1_Y_B_sg13g2_a22oi_1_Y_A1_sg13g2_a221oi_1_Y
+ uo_out_sg13g2_dfrbpq_1_Q_3_D_sg13g2_o21ai_1_Y_B1_sg13g2_nand2_1_Y_B_sg13g2_a22oi_1_Y_A1_sg13g2_a221oi_1_Y/C1
+ uo_out_sg13g2_dfrbpq_1_Q_3_D_sg13g2_o21ai_1_Y_B1_sg13g2_nand2_1_Y_B_sg13g2_a22oi_1_Y/A1
+ serial_b\[0\]_sg13g2_xnor2_1_B/B uo_out_sg13g2_dfrbpq_1_Q_6_D_sg13g2_a21oi_1_Y_A2_sg13g2_a21o_1_X_A2_sg13g2_and2_1_X_B_sg13g2_a22oi_1_Y/A2
+ uo_out_sg13g2_dfrbpq_1_Q_D_sg13g2_a21oi_1_Y_B1_sg13g2_a21oi_1_Y_A1_sg13g2_nand3_1_Y_A_sg13g2_nand2_1_Y/B
+ VDD serial_b\[0\]_sg13g2_xnor2_1_B/A VSS sg13g2_a221oi_1
Xmisr\[0\]_sg13g2_dfrbpq_1_Q_D_sg13g2_a22oi_1_Y_B2_sg13g2_o21ai_1_Y_A2_sg13g2_a21oi_1_Y_B1_sg13g2_a21oi_1_Y
+ VDD VSS misr\[0\]_sg13g2_dfrbpq_1_Q_D_sg13g2_a22oi_1_Y_B2_sg13g2_o21ai_1_Y_A2_sg13g2_a21oi_1_Y/A2
+ uo_out_sg13g2_dfrbpq_1_Q_5_D_sg13g2_a21oi_1_Y_A2_sg13g2_o21ai_1_Y_A2_sg13g2_mux2_1_X/A0
+ misr\[0\]_sg13g2_dfrbpq_1_Q_D_sg13g2_a22oi_1_Y_B2_sg13g2_o21ai_1_Y_A2_sg13g2_a21oi_1_Y_B1_sg13g2_a21oi_1_Y/B1
+ misr\[0\]_sg13g2_dfrbpq_1_Q_D_sg13g2_a22oi_1_Y_B2_sg13g2_o21ai_1_Y_A2_sg13g2_a21oi_1_Y/B1
+ sg13g2_a21oi_1
Xuo_out_sg13g2_dfrbpq_1_Q_D_sg13g2_a21oi_1_Y_B1_sg13g2_a21oi_1_Y_A1_sg13g2_nand3_1_Y_B_sg13g2_a221oi_1_Y_C1_sg13g2_o21ai_1_Y_A1_sg13g2_nor2_1_B_Y_sg13g2_a22oi_1_B2_Y_sg13g2_and2_1_B
+ uo_out_sg13g2_dfrbpq_1_Q_4_D_sg13g2_a21oi_1_Y_A2_sg13g2_a21o_1_X_B1_sg13g2_and2_1_X/B
+ VSS VDD uo_out_sg13g2_dfrbpq_1_Q_D_sg13g2_a21oi_1_Y_B1_sg13g2_a21oi_1_Y_A1_sg13g2_nand3_1_Y_B_sg13g2_a221oi_1_Y_C1_sg13g2_o21ai_1_Y_A1_sg13g2_nor2_1_B_Y_sg13g2_a22oi_1_B2/Y
+ uo_out_sg13g2_dfrbpq_1_Q_D_sg13g2_a21oi_1_Y_B1_sg13g2_a21oi_1_Y_A1_sg13g2_nand3_1_Y_B_sg13g2_a221oi_1_Y_C1_sg13g2_o21ai_1_Y_A1_sg13g2_nor2_1_B_Y_sg13g2_a22oi_1_B2_Y_sg13g2_and2_1_B/A
+ sg13g2_and2_1
Xclkbuf_5_22__f_clk clkbuf_5_22__f_clk/X VSS clkbuf_4_11_0_clk/X VDD sg13g2_buf_4
Xscan_reg\[4\]_sg13g2_dfrbpq_1_Q VDD scan_reg\[4\]_sg13g2_dfrbpq_1_Q/D scan_reg\[4\]_sg13g2_inv_1_A/A
+ clkbuf_5_18__f_clk/X VSS rst_n sg13g2_dfrbpq_1
Xoperation\[3\]_sg13g2_dfrbpq_1_Q_D_sg13g2_a21oi_1_Y_A1_sg13g2_a21oi_1_A1_Y_sg13g2_nor2_1_B_Y_sg13g2_a21oi_1_B1_Y_sg13g2_nand3_1_A
+ VDD operation\[3\]_sg13g2_dfrbpq_1_Q_D_sg13g2_a21oi_1_Y_A1_sg13g2_a21oi_1_A1_Y_sg13g2_nor2_1_B_Y_sg13g2_a21oi_1_B1_Y_sg13g2_nand3_1_A/Y
+ operation\[3\]_sg13g2_dfrbpq_1_Q_D_sg13g2_a21oi_1_Y_A1_sg13g2_a21oi_1_A1_Y_sg13g2_nor2_1_B_Y_sg13g2_a21oi_1_B1_Y_sg13g2_nand3_1_A/B
+ operation\[3\]_sg13g2_dfrbpq_1_Q_D_sg13g2_a21oi_1_Y_A1_sg13g2_a21oi_1_A1_Y_sg13g2_nor2_1_B_Y_sg13g2_a21oi_1_B1_Y_sg13g2_nand3_1_A/C
+ operation\[3\]_sg13g2_dfrbpq_1_Q_D_sg13g2_a21oi_1_Y_A1_sg13g2_a21oi_1_A1_Y_sg13g2_nor2_1_B_Y_sg13g2_a21oi_1_B1/Y
+ VSS sg13g2_nand3_1
Xzero_flag_sg13g2_dfrbpq_1_Q_D_sg13g2_o21ai_1_Y_A1_sg13g2_nand3_1_Y VDD zero_flag_sg13g2_dfrbpq_1_Q_D_sg13g2_o21ai_1_Y/A1
+ uo_out_sg13g2_dfrbpq_1_Q_5_D_sg13g2_a21oi_1_Y/A2 uo_out_sg13g2_dfrbpq_1_Q_6_D_sg13g2_a21oi_1_Y/A2
+ uo_out_sg13g2_dfrbpq_1_Q_4_D_sg13g2_a21oi_1_Y/A2 VSS sg13g2_nand3_1
Xoverflow_flag_sg13g2_dfrbpq_1_Q_D_sg13g2_inv_1_Y_A_sg13g2_o21ai_1_Y_B1_sg13g2_nand3_1_Y_C_sg13g2_a21oi_1_Y_A1_sg13g2_o21ai_1_A2_B1_sg13g2_o21ai_1_A1_B1_sg13g2_a22oi_1_Y
+ overflow_flag_sg13g2_dfrbpq_1_Q_D_sg13g2_inv_1_Y_A_sg13g2_o21ai_1_Y_B1_sg13g2_nand3_1_Y_C_sg13g2_a21oi_1_Y_A1_sg13g2_o21ai_1_A2_B1_sg13g2_o21ai_1_A1/B1
+ serial_opcode\[0\]_sg13g2_o21ai_1_A1/Y VDD overflow_flag_sg13g2_dfrbpq_1_Q_D_sg13g2_inv_1_Y_A_sg13g2_o21ai_1_Y_B1_sg13g2_nand3_1_Y_A_sg13g2_and4_1_A_C_sg13g2_o21ai_1_Y/A2
+ serial_a\[3\]_sg13g2_dfrbpq_1_Q/Q VSS uo_out_sg13g2_dfrbpq_1_Q_6_D_sg13g2_a21oi_1_Y_A2_sg13g2_a21o_1_X_A2_sg13g2_and2_1_X_B_sg13g2_a22oi_1_Y_B2_sg13g2_and2_1_X_B_sg13g2_o21ai_1_Y_A2_sg13g2_a221oi_1_Y/C1
+ sg13g2_a22oi_1
Xmisr\[4\]_sg13g2_inv_1_A_Y_sg13g2_xnor2_1_A_B_sg13g2_o21ai_1_Y_A1_sg13g2_a21oi_1_Y_A2_sg13g2_a21oi_1_Y_A1_sg13g2_nor2b_1_Y
+ misr\[4\]_sg13g2_inv_1_A_Y_sg13g2_xnor2_1_A_B_sg13g2_o21ai_1_Y_A1_sg13g2_a21oi_1_Y_A2_sg13g2_a21oi_1_Y_A1_sg13g2_nor2b_1_Y/A
+ bist_a\[7\]_sg13g2_dfrbpq_1_Q_D_sg13g2_o21ai_1_Y_A1_sg13g2_o21ai_1_A1_B1_sg13g2_a21oi_1_Y_A2_sg13g2_and2_1_X/B
+ VDD misr\[4\]_sg13g2_inv_1_A_Y_sg13g2_xnor2_1_A_B_sg13g2_o21ai_1_Y_A1_sg13g2_a21oi_1_Y_A2_sg13g2_a21oi_1_Y/A1
+ VSS sg13g2_nor2b_1
Xscan_reg\[23\]_sg13g2_dfrbpq_1_Q_D_sg13g2_a221oi_1_Y scan_reg\[23\]_sg13g2_nor2_1_A_1/Y
+ scan_reg\[23\]_sg13g2_dfrbpq_1_Q/D scan_reg\[24\]_sg13g2_inv_1_A/Y scan_out_sg13g2_a22oi_1_A1/B1
+ uo_out_sg13g2_dfrbpq_1_Q_D_sg13g2_a21oi_1_Y/A1 VDD ui_in[3] VSS sg13g2_a221oi_1
Xuo_out_sg13g2_dfrbpq_1_Q_D_sg13g2_a21oi_1_Y_B1_sg13g2_a21oi_1_Y_A1_sg13g2_nand3_1_Y_B_sg13g2_a221oi_1_Y_C1_sg13g2_o21ai_1_Y_A1_sg13g2_nor2_1_B_Y_sg13g2_a22oi_1_B2_B1_sg13g2_nand3_1_Y_C_sg13g2_a21oi_1_A2
+ VDD VSS uo_out_sg13g2_dfrbpq_1_Q_D_sg13g2_a21oi_1_Y_B1_sg13g2_a21oi_1_Y_A1_sg13g2_nand3_1_Y_B_sg13g2_a221oi_1_Y_C1_sg13g2_o21ai_1_Y_A1_sg13g2_nor2_1_B_Y_sg13g2_a22oi_1_B2_B1_sg13g2_nand3_1_Y/C
+ uo_out_sg13g2_dfrbpq_1_Q_5_D_sg13g2_a21oi_1_Y_A2_sg13g2_o21ai_1_Y_B1_sg13g2_or2_1_X_B_sg13g2_nand2_1_Y_A_sg13g2_a221oi_1_Y_C1_sg13g2_nand4_1_Y_B_sg13g2_o21ai_1_Y_B1_sg13g2_a21o_1_X/A1
+ carry_flag_sg13g2_o21ai_1_A1_B1_sg13g2_nand2_1_Y_A_sg13g2_nand3_1_Y_B_sg13g2_nand3_1_C_Y_sg13g2_o21ai_1_B1_A2_sg13g2_nor3_1_Y_C_sg13g2_nor4_1_Y_D_sg13g2_nand2_1_Y/A
+ carry_flag_sg13g2_o21ai_1_A1_B1_sg13g2_nand2_1_Y_B_sg13g2_a21oi_1_Y_A2_sg13g2_a21oi_1_Y_B1_sg13g2_o21ai_1_B1/A2
+ sg13g2_a21oi_1
Xuo_out_sg13g2_dfrbpq_1_Q_3_D_sg13g2_o21ai_1_Y VSS VDD uo_out_sg13g2_dfrbpq_1_Q_3/D
+ uo_out_sg13g2_dfrbpq_1_Q_3_D_sg13g2_o21ai_1_Y/B1 ui_in[2] uo_out_sg13g2_dfrbpq_1_Q_3_D_sg13g2_o21ai_1_Y/A1
+ sg13g2_o21ai_1
Xfault_counter\[6\]_sg13g2_dfrbpq_1_Q VDD fault_counter\[6\]_sg13g2_dfrbpq_1_Q/D scan_out_sg13g2_a22oi_1_A1_1/B2
+ clkbuf_5_14__f_clk/X VSS rst_n sg13g2_dfrbpq_1
Xscan_reg\[25\]_sg13g2_o21ai_1_A1_B1_sg13g2_nand2b_1_Y VSS uo_out[5] scan_reg\[25\]_sg13g2_o21ai_1_A1/B1
+ ui_in[3] VDD sg13g2_nand2b_1
Xmisr\[6\]_sg13g2_dfrbpq_1_Q_D_sg13g2_o21ai_1_Y_A2_sg13g2_xnor2_1_Y_B_sg13g2_a22oi_1_Y_A1_sg13g2_and4_1_X_A_sg13g2_nand2_1_Y
+ misr\[6\]_sg13g2_dfrbpq_1_Q_D_sg13g2_o21ai_1_Y_A2_sg13g2_xnor2_1_Y_B_sg13g2_a22oi_1_Y_A1_sg13g2_and4_1_X/A
+ VDD misr\[1\]_sg13g2_inv_1_A_Y_sg13g2_xnor2_1_A_B_sg13g2_o21ai_1_Y_A2_sg13g2_nand3_1_Y_C_sg13g2_a22oi_1_Y/A1
+ VSS misr\[6\]_sg13g2_dfrbpq_1_Q_D_sg13g2_o21ai_1_Y_A2_sg13g2_xnor2_1_Y_B_sg13g2_a22oi_1_Y_A1_sg13g2_and4_1_X_A_sg13g2_nand2_1_Y/B
+ sg13g2_nand2_1
Xoverflow_flag_sg13g2_dfrbpq_1_Q_D_sg13g2_inv_1_Y_A_sg13g2_o21ai_1_Y_B1_sg13g2_nand3_1_Y_A_sg13g2_nand2_1_Y_B_sg13g2_a21oi_1_Y_A2_sg13g2_o21ai_1_Y_B1_sg13g2_a22oi_1_B2_Y_sg13g2_nand4_1_C_D_sg13g2_a21oi_1_Y
+ VDD VSS overflow_flag_sg13g2_dfrbpq_1_Q_D_sg13g2_inv_1_Y_A_sg13g2_o21ai_1_Y_B1_sg13g2_nand3_1_Y_A_sg13g2_and4_1_A_C_sg13g2_o21ai_1_Y/A2
+ serial_b\[6\]_sg13g2_and2_1_A/X overflow_flag_sg13g2_dfrbpq_1_Q_D_sg13g2_inv_1_Y_A_sg13g2_o21ai_1_Y_B1_sg13g2_nand3_1_Y_A_sg13g2_nand2_1_Y_B_sg13g2_a21oi_1_Y_A2_sg13g2_o21ai_1_Y_B1_sg13g2_a22oi_1_B2_Y_sg13g2_nand4_1_C_D_sg13g2_a21oi_1_Y/B1
+ overflow_flag_sg13g2_dfrbpq_1_Q_D_sg13g2_inv_1_Y_A_sg13g2_o21ai_1_Y_B1_sg13g2_nand3_1_Y_A_sg13g2_nand2_1_Y_B_sg13g2_a21oi_1_Y_A2_sg13g2_o21ai_1_Y_B1_sg13g2_a22oi_1_B2_Y_sg13g2_nand4_1_C/D
+ sg13g2_a21oi_1
Xmisr\[1\]_sg13g2_dfrbpq_1_Q_D_sg13g2_a22oi_1_Y_B2_sg13g2_o21ai_1_Y VSS VDD misr\[1\]_sg13g2_dfrbpq_1_Q_D_sg13g2_a22oi_1_Y/B2
+ misr\[1\]_sg13g2_dfrbpq_1_Q_D_sg13g2_a22oi_1_Y_B2_sg13g2_o21ai_1_Y/B1 misr\[1\]_sg13g2_dfrbpq_1_Q_D_sg13g2_a22oi_1_Y_B2_sg13g2_o21ai_1_Y/A2
+ misr\[0\]_sg13g2_dfrbpq_1_Q/Q sg13g2_o21ai_1
Xserial_b\[4\]_sg13g2_dfrbpq_1_Q_D_sg13g2_mux2_1_X serial_b\[5\]_sg13g2_nand2b_1_B/B
+ serial_b\[4\]_sg13g2_dfrbpq_1_Q/D ui_in[1] VDD VSS serial_b\[4\]_sg13g2_nand2_1_A/A
+ sg13g2_mux2_1
Xscan_reg\[21\]_sg13g2_nor2_1_A_1 scan_reg\[21\]_sg13g2_nor2_1_A/A VDD scan_reg\[21\]_sg13g2_nor2_1_A_1/Y
+ VSS scan_reg\[41\]_sg13g2_nor2_1_A/B sg13g2_nor2_1
Xserial_opcode\[0\]_sg13g2_o21ai_1_A1_B1_sg13g2_nand2b_1_Y VSS serial_opcode\[2\]_sg13g2_nor3_1_A/C
+ serial_opcode\[0\]_sg13g2_o21ai_1_A1/B1 serial_opcode\[3\]_sg13g2_nor2_1_B/Y VDD
+ sg13g2_nand2b_1
Xserial_a\[6\]_sg13g2_dfrbpq_1_Q VDD serial_a\[6\]_sg13g2_dfrbpq_1_Q/D serial_b\[6\]_sg13g2_and2_1_A/B
+ clkbuf_5_20__f_clk/X VSS rst_n sg13g2_dfrbpq_1
Xuo_out_sg13g2_dfrbpq_1_Q_5_D_sg13g2_a21oi_1_Y_A2_sg13g2_o21ai_1_Y_B1_sg13g2_or2_1_X_B_sg13g2_nand2_1_Y_A_sg13g2_a221oi_1_Y
+ uo_out_sg13g2_dfrbpq_1_Q_5_D_sg13g2_a21oi_1_Y_A2_sg13g2_o21ai_1_Y_B1_sg13g2_or2_1_X_B_sg13g2_nand2_1_Y_A_sg13g2_a221oi_1_Y/C1
+ uo_out_sg13g2_dfrbpq_1_Q_5_D_sg13g2_a21oi_1_Y_A2_sg13g2_o21ai_1_Y_B1_sg13g2_or2_1_X_B_sg13g2_nand2_1_Y/A
+ uo_out_sg13g2_dfrbpq_1_Q_5_D_sg13g2_a21oi_1_Y_A2_sg13g2_o21ai_1_Y_B1_sg13g2_or2_1_X_B_sg13g2_nand2_1_Y_A_sg13g2_a221oi_1_Y/B2
+ uo_out_sg13g2_dfrbpq_1_Q_D_sg13g2_a21oi_1_Y_B1_sg13g2_a21oi_1_Y_A1_sg13g2_nand3_1_Y_B_sg13g2_a221oi_1_Y/B2
+ uo_out_sg13g2_dfrbpq_1_Q_D_sg13g2_a21oi_1_Y_B1_sg13g2_a21oi_1_Y_A1_sg13g2_nand3_1_Y_A_sg13g2_nand2_1_Y/B
+ VDD serial_a\[5\]_sg13g2_dfrbpq_1_Q/Q VSS sg13g2_a221oi_1
Xuo_out_sg13g2_dfrbpq_1_Q_5_D_sg13g2_a21oi_1_Y_A2_sg13g2_o21ai_1_Y_B1_sg13g2_or2_1_X_B_sg13g2_nand2_1_Y_B_sg13g2_a22oi_1_Y_B2_sg13g2_nor2_1_Y
+ uo_out_sg13g2_dfrbpq_1_Q_5_D_sg13g2_a21oi_1_Y_A2_sg13g2_o21ai_1_Y_B1_sg13g2_or2_1_X_B_sg13g2_nand2_1_Y_B_sg13g2_a22oi_1_Y_B2_sg13g2_nor2_1_Y/A
+ VDD uo_out_sg13g2_dfrbpq_1_Q_5_D_sg13g2_a21oi_1_Y_A2_sg13g2_o21ai_1_Y_B1_sg13g2_or2_1_X_B_sg13g2_nand2_1_Y_B_sg13g2_a22oi_1_Y/B2
+ VSS uo_out_sg13g2_dfrbpq_1_Q_D_sg13g2_a21oi_1_Y_B1_sg13g2_a21oi_1_Y_A1_sg13g2_nand3_1_Y_B_sg13g2_a221oi_1_Y_C1_sg13g2_o21ai_1_Y/A1
+ sg13g2_nor2_1
Xuo_out_sg13g2_dfrbpq_1_Q_D_sg13g2_a21oi_1_Y_B1_sg13g2_a21oi_1_Y_A1_sg13g2_nand3_1_Y_B_sg13g2_a221oi_1_Y_C1_sg13g2_o21ai_1_Y_A1_sg13g2_a21oi_1_Y
+ VDD VSS uo_out_sg13g2_dfrbpq_1_Q_D_sg13g2_a21oi_1_Y_B1_sg13g2_a21oi_1_Y_A1_sg13g2_nand3_1_Y_B_sg13g2_a221oi_1_Y_C1_sg13g2_o21ai_1_Y_A1_sg13g2_a21oi_1_Y/A2
+ carry_flag_sg13g2_o21ai_1_A1_B1_sg13g2_nand2_1_Y_A_sg13g2_nand3_1_Y_A_sg13g2_a21oi_1_B1_Y_sg13g2_a22oi_1_B2/A1
+ carry_flag_sg13g2_o21ai_1_A1_B1_sg13g2_nand2_1_Y_B_sg13g2_a21oi_1_Y/A1 uo_out_sg13g2_dfrbpq_1_Q_D_sg13g2_a21oi_1_Y_B1_sg13g2_a21oi_1_Y_A1_sg13g2_nand3_1_Y_B_sg13g2_a221oi_1_Y_C1_sg13g2_o21ai_1_Y/A1
+ sg13g2_a21oi_1
Xmisr\[0\]_sg13g2_dfrbpq_1_Q_D_sg13g2_a22oi_1_Y_B2_sg13g2_o21ai_1_Y_A2_sg13g2_a21oi_1_Y_A2_sg13g2_nor2b_1_Y_A_sg13g2_nor4_1_Y_D_sg13g2_nand2_1_Y
+ bist_a\[7\]_sg13g2_dfrbpq_1_Q_D_sg13g2_o21ai_1_Y_A1_sg13g2_o21ai_1_A1_B1_sg13g2_a21oi_1_Y_B1_sg13g2_nor3_1_Y/C
+ VDD bist_a\[1\]_sg13g2_dfrbpq_1_Q/Q VSS bist_a\[0\]_sg13g2_dfrbpq_1_Q/Q sg13g2_nand2_1
Xuo_out_sg13g2_dfrbpq_1_Q_6_D_sg13g2_a21oi_1_Y_A2_sg13g2_a21o_1_X_A2_sg13g2_and2_1_X_B_sg13g2_a22oi_1_Y
+ uo_out_sg13g2_dfrbpq_1_Q_6_D_sg13g2_a21oi_1_Y_A2_sg13g2_a21o_1_X_A2_sg13g2_and2_1_X/B
+ uo_out_sg13g2_dfrbpq_1_Q_6_D_sg13g2_a21oi_1_Y_A2_sg13g2_a21o_1_X_A2_sg13g2_and2_1_X_B_sg13g2_a22oi_1_Y/A2
+ VDD uo_out_sg13g2_dfrbpq_1_Q_6_D_sg13g2_a21oi_1_Y_A2_sg13g2_a21o_1_X_A2_sg13g2_and2_1_X_B_sg13g2_a22oi_1_Y/B1
+ serial_b\[4\]_sg13g2_nand2_1_A/A VSS uo_out_sg13g2_dfrbpq_1_Q_6_D_sg13g2_a21oi_1_Y_A2_sg13g2_a21o_1_X_A2_sg13g2_and2_1_X_B_sg13g2_a22oi_1_Y/B2
+ sg13g2_a22oi_1
Xcycle_counter\[4\]_sg13g2_dfrbpq_1_Q_D_sg13g2_xnor2_1_Y cycle_counter\[4\]_sg13g2_dfrbpq_1_Q/D
+ cycle_counter\[4\]_sg13g2_dfrbpq_1_Q_D_sg13g2_xnor2_1_Y/B VDD scan_reg\[54\]_sg13g2_dfrbpq_1_Q_D_sg13g2_a221oi_1_Y/A1
+ VSS sg13g2_xnor2_1
Xbist_a\[7\]_sg13g2_dfrbpq_1_Q_D_sg13g2_o21ai_1_Y_A1_sg13g2_nand2_1_A_Y_sg13g2_a221oi_1_B2_A2_sg13g2_xnor2_1_Y_A_sg13g2_and2_1_X_B_sg13g2_nand2_1_B
+ bist_a\[7\]_sg13g2_dfrbpq_1_Q_D_sg13g2_o21ai_1_Y_A1_sg13g2_nand2_1_A_Y_sg13g2_a221oi_1_B2_Y_sg13g2_o21ai_1_B1_A1_sg13g2_nor3_1_Y/A
+ VDD bist_a\[7\]_sg13g2_or2_1_A/X VSS bist_a\[7\]_sg13g2_dfrbpq_1_Q_D_sg13g2_o21ai_1_Y_A1_sg13g2_nand2_1_A_Y_sg13g2_a221oi_1_B2_A2_sg13g2_xnor2_1_Y_A_sg13g2_and2_1_X/B
+ sg13g2_nand2_1
Xuo_out_sg13g2_dfrbpq_1_Q_4_D_sg13g2_a21oi_1_Y_A2_sg13g2_a21o_1_X_A2_sg13g2_a21o_1_X_A1_sg13g2_and2_1_X
+ uo_out_sg13g2_dfrbpq_1_Q_4_D_sg13g2_a21oi_1_Y_A2_sg13g2_a21o_1_X_A2_sg13g2_a21o_1_X/A1
+ VSS VDD misr\[1\]_sg13g2_inv_1_A_Y_sg13g2_xnor2_1_A_B_sg13g2_o21ai_1_Y_B1_sg13g2_nand4_1_Y/A
+ uio_in[0] sg13g2_and2_1
Xbist_a\[5\]_sg13g2_dfrbpq_1_Q VDD bist_a\[5\]_sg13g2_dfrbpq_1_Q/D bist_a\[5\]_sg13g2_dfrbpq_1_Q/Q
+ clkload0/A VSS rst_n sg13g2_dfrbpq_1
Xclkbuf_5_3__f_clk clkbuf_5_3__f_clk/X VSS clkbuf_4_1_0_clk/X VDD sg13g2_buf_4
Xoperand_b\[3\]_sg13g2_nor2_1_A operand_b\[3\]_sg13g2_nor2_1_A/A VDD operand_b\[3\]_sg13g2_nor2_1_A/Y
+ VSS ui_in[2] sg13g2_nor2_1
Xscan_reg\[27\]_sg13g2_dfrbpq_1_Q_D_sg13g2_o21ai_1_Y VSS VDD scan_reg\[27\]_sg13g2_dfrbpq_1_Q/D
+ scan_reg\[27\]_sg13g2_a22oi_1_B1/Y scan_reg\[28\]_sg13g2_nand2b_1_B/Y scan_reg\[27\]_sg13g2_dfrbpq_1_Q_D_sg13g2_o21ai_1_Y/A1
+ sg13g2_o21ai_1
Xserial_opcode\[2\]_sg13g2_dfrbpq_1_Q_D_sg13g2_o21ai_1_Y_B1_sg13g2_nand2_1_Y serial_opcode\[2\]_sg13g2_dfrbpq_1_Q_D_sg13g2_o21ai_1_Y/B1
+ VDD serial_opcode\[3\]_sg13g2_nor2_1_B/B VSS ui_in[1] sg13g2_nand2_1
Xuo_out_sg13g2_dfrbpq_1_Q_5_D_sg13g2_a21oi_1_Y_A2_sg13g2_o21ai_1_Y_B1_sg13g2_or2_1_X_B_sg13g2_nand2_1_Y_A_sg13g2_a221oi_1_Y_C1_sg13g2_nand4_1_Y_C_sg13g2_a22oi_1_Y
+ uo_out_sg13g2_dfrbpq_1_Q_5_D_sg13g2_a21oi_1_Y_A2_sg13g2_o21ai_1_Y_B1_sg13g2_or2_1_X_B_sg13g2_nand2_1_Y_A_sg13g2_a221oi_1_Y_C1_sg13g2_nand4_1_Y/C
+ overflow_flag_sg13g2_dfrbpq_1_Q_D_sg13g2_inv_1_Y_A_sg13g2_o21ai_1_Y_B1_sg13g2_nand3_1_Y_A_sg13g2_and4_1_A_D_sg13g2_a221oi_1_Y/A2
+ VDD overflow_flag_sg13g2_dfrbpq_1_Q_D_sg13g2_inv_1_Y_A_sg13g2_o21ai_1_Y_B1_sg13g2_nand3_1_Y_A_sg13g2_and4_1_A_C_sg13g2_o21ai_1_Y/A2
+ serial_b\[4\]_sg13g2_nand2_1_A/B VSS overflow_flag_sg13g2_dfrbpq_1_Q_D_sg13g2_inv_1_Y_A_sg13g2_o21ai_1_Y_B1_sg13g2_nand3_1_Y_A_sg13g2_nand2_1_Y_B_sg13g2_a21oi_1_Y_A2_sg13g2_o21ai_1_Y/A1
+ sg13g2_a22oi_1
Xuo_out_sg13g2_dfrbpq_1_Q_5_D_sg13g2_a21oi_1_Y_A2_sg13g2_o21ai_1_Y_B1_sg13g2_or2_1_X_B_sg13g2_nand2_1_Y_A_sg13g2_a221oi_1_Y_B2_sg13g2_xor2_1_X_A_sg13g2_nand2_1_Y_A_sg13g2_nand3_1_B_Y_sg13g2_a21oi_1_A2
+ VDD VSS uo_out_sg13g2_dfrbpq_1_Q_5_D_sg13g2_a21oi_1_Y_A2_sg13g2_o21ai_1_Y_B1_sg13g2_or2_1_X_B_sg13g2_nand2_1_Y_A_sg13g2_a221oi_1_Y_B2_sg13g2_xor2_1_X_A_sg13g2_nand2_1_Y_A_sg13g2_nand3_1_B/Y
+ serial_b\[5\]_sg13g2_nand2b_1_B/Y carry_flag_sg13g2_o21ai_1_A1_B1_sg13g2_nand2_1_Y_A_sg13g2_nand3_1_Y_B_sg13g2_nand3_1_C_Y_sg13g2_o21ai_1_B1_A2_sg13g2_nor3_1_Y_C_sg13g2_nor4_1_Y_D_sg13g2_nand2_1_Y/A
+ uo_out_sg13g2_dfrbpq_1_Q_5_D_sg13g2_a21oi_1_Y_A2_sg13g2_o21ai_1_Y_B1_sg13g2_or2_1_X_B_sg13g2_nand2_1_Y_A_sg13g2_a221oi_1_Y_B2_sg13g2_xor2_1_X_A_sg13g2_nand2_1_Y_A_sg13g2_nand3_1_B_Y_sg13g2_a21oi_1_A2/Y
+ sg13g2_a21oi_1
Xserial_a\[2\]_sg13g2_dfrbpq_1_Q_D_sg13g2_mux2_1_X serial_a\[3\]_sg13g2_dfrbpq_1_Q/Q
+ serial_a\[2\]_sg13g2_dfrbpq_1_Q/D ui_in[1] VDD VSS serial_b\[2\]_sg13g2_xor2_1_A/B
+ sg13g2_mux2_1
Xuo_out_sg13g2_dfrbpq_1_Q_D_sg13g2_a21oi_1_Y_B1_sg13g2_a21oi_1_Y_A1_sg13g2_nand3_1_Y_B_sg13g2_a221oi_1_Y_B1_sg13g2_xnor2_1_Y_A_sg13g2_a21oi_1_Y_B1_sg13g2_nor2b_1_Y
+ serial_b\[2\]_sg13g2_xor2_1_A/A serial_b\[2\]_sg13g2_xor2_1_A/B VDD uo_out_sg13g2_dfrbpq_1_Q_D_sg13g2_a21oi_1_Y_B1_sg13g2_a21oi_1_Y_A1_sg13g2_nand3_1_Y_B_sg13g2_a221oi_1_Y_B1_sg13g2_xnor2_1_Y_A_sg13g2_a21oi_1_Y/B1
+ VSS sg13g2_nor2b_1
Xscan_reg\[25\]_sg13g2_dfrbpq_1_Q VDD scan_reg\[25\]_sg13g2_dfrbpq_1_Q/D scan_reg\[25\]_sg13g2_nor2_1_A/A
+ clkbuf_5_26__f_clk/X VSS rst_n sg13g2_dfrbpq_1
Xuo_out_sg13g2_dfrbpq_1_Q_D_sg13g2_a21oi_1_Y_B1_sg13g2_a21oi_1_Y_A2_sg13g2_nand3b_1_Y
+ uo_out_sg13g2_dfrbpq_1_Q_D_sg13g2_a21oi_1_Y_B1_sg13g2_a21oi_1_Y_A2_sg13g2_nand3b_1_Y/A_N
+ uo_out_sg13g2_dfrbpq_1_Q_D_sg13g2_a21oi_1_Y_B1_sg13g2_a21oi_1_Y/A2 VDD VSS uo_out_sg13g2_dfrbpq_1_Q_D_sg13g2_a21oi_1_Y_B1_sg13g2_a21oi_1_Y_A2_sg13g2_nand3b_1_Y/B
+ uo_out_sg13g2_dfrbpq_1_Q_D_sg13g2_a21oi_1_Y_B1_sg13g2_a21oi_1_Y_A2_sg13g2_nand3b_1_Y/C
+ sg13g2_nand3b_1
Xclkbuf_4_15_0_clk clkbuf_4_15_0_clk/X VSS clkbuf_0_clk/X VDD sg13g2_buf_4
Xscan_reg\[1\]_sg13g2_o21ai_1_A1_1 VSS VDD scan_reg\[1\]_sg13g2_o21ai_1_A1_1/Y scan_reg\[1\]_sg13g2_o21ai_1_A1_1/B1
+ scan_reg\[41\]_sg13g2_nor2_1_A/B scan_reg\[1\]_sg13g2_dfrbpq_1_Q/Q sg13g2_o21ai_1
Xscan_reg\[56\]_sg13g2_inv_1_A scan_reg\[56\]_sg13g2_inv_1_A/Y scan_reg\[56\]_sg13g2_inv_1_A/A
+ VSS VDD sg13g2_inv_1
Xserial_opcode\[1\]_sg13g2_dfrbpq_1_Q_D_sg13g2_a21oi_1_Y VDD VSS ui_in[1] serial_opcode\[2\]_sg13g2_inv_1_A/Y
+ serial_opcode\[1\]_sg13g2_dfrbpq_1_Q_D_sg13g2_a21oi_1_Y/B1 serial_opcode\[1\]_sg13g2_dfrbpq_1_Q/D
+ sg13g2_a21oi_1
Xcarry_flag_sg13g2_o21ai_1_A1_B1_sg13g2_nand2_1_Y_A_sg13g2_nand3_1_Y_B_sg13g2_nand3_1_C_A_sg13g2_o21ai_1_B1_A2_sg13g2_nor3_1_Y
+ carry_flag_sg13g2_o21ai_1_A1_B1_sg13g2_nand2_1_Y_A_sg13g2_nand3_1_Y_B_sg13g2_nand3_1_C_A_sg13g2_o21ai_1_B1_A2_sg13g2_nor3_1_Y/A
+ carry_flag_sg13g2_o21ai_1_A1_B1_sg13g2_nand2_1_Y_A_sg13g2_nand3_1_Y_B_sg13g2_nand3_1_C_A_sg13g2_o21ai_1_B1/A2
+ carry_flag_sg13g2_o21ai_1_A1_B1_sg13g2_nand2_1_Y_A_sg13g2_nand3_1_Y_B_sg13g2_nand3_1_Y_A_sg13g2_nor3_1_A/B
+ carry_flag_sg13g2_o21ai_1_A1_B1_sg13g2_nand2_1_Y_A_sg13g2_nand3_1_Y_B_sg13g2_nand3_1_Y_A_sg13g2_nor3_1_A/C
+ VDD VSS sg13g2_nor3_1
Xcarry_flag_sg13g2_o21ai_1_A1_B1_sg13g2_nand2_1_Y_A_sg13g2_nand3_1_Y_B_sg13g2_nand3_1_C
+ VDD carry_flag_sg13g2_o21ai_1_A1_B1_sg13g2_nand2_1_Y_A_sg13g2_nand3_1_Y_B_sg13g2_nand3_1_C/Y
+ carry_flag_sg13g2_o21ai_1_A1_B1_sg13g2_nand2_1_Y_A_sg13g2_nand3_1_Y/A carry_flag_sg13g2_o21ai_1_A1_B1_sg13g2_nand2_1_Y_A_sg13g2_nand3_1_Y/B
+ carry_flag_sg13g2_o21ai_1_A1_B1_sg13g2_nand2_1_Y_A_sg13g2_nand3_1_Y_B_sg13g2_nand3_1_C/A
+ VSS sg13g2_nand3_1
Xscan_reg\[45\]_sg13g2_dfrbpq_1_Q VDD scan_reg\[45\]_sg13g2_dfrbpq_1_Q/D scan_reg\[45\]_sg13g2_nor2_1_A/A
+ clkbuf_5_8__f_clk/X VSS rst_n sg13g2_dfrbpq_1
Xbist_a\[7\]_sg13g2_dfrbpq_1_Q_D_sg13g2_o21ai_1_Y_A1_sg13g2_nand2_1_A_B_sg13g2_o21ai_1_A2
+ VSS VDD bist_a\[7\]_sg13g2_dfrbpq_1_Q_D_sg13g2_o21ai_1_Y_A1_sg13g2_nand2_1_A_B_sg13g2_o21ai_1_A2/Y
+ bist_a\[7\]_sg13g2_dfrbpq_1_Q_D_sg13g2_o21ai_1_Y_A1_sg13g2_nand2_1_A_B_sg13g2_o21ai_1_A2/B1
+ bist_a\[7\]_sg13g2_dfrbpq_1_Q_D_sg13g2_o21ai_1_Y_A1_sg13g2_nand2_1_A/B bist_a\[5\]_sg13g2_dfrbpq_1_Q/Q
+ sg13g2_o21ai_1
Xoperand_b\[6\]_sg13g2_mux2_1_A0 serial_b\[6\]_sg13g2_and2_1_A/A operand_b\[6\]_sg13g2_mux2_1_A0/X
+ ui_in[2] VDD VSS operand_b\[6\]_sg13g2_mux2_1_A0/A0 sg13g2_mux2_1
Xoverflow_flag_sg13g2_dfrbpq_1_Q_D_sg13g2_inv_1_Y_A_sg13g2_o21ai_1_Y_B1_sg13g2_nand3_1_Y_B_sg13g2_o21ai_1_Y
+ VSS VDD overflow_flag_sg13g2_dfrbpq_1_Q_D_sg13g2_inv_1_Y_A_sg13g2_o21ai_1_Y_B1_sg13g2_nand3_1_Y/B
+ carry_flag_sg13g2_o21ai_1_A1_B1_sg13g2_nand2_1_Y_A_sg13g2_nand3_1_Y/C carry_flag_sg13g2_o21ai_1_A1_B1_sg13g2_nand2_1_Y_A_sg13g2_nand3_1_Y_B_sg13g2_nand3_1_Y_A_sg13g2_nor3_1_A/Y
+ carry_flag_sg13g2_o21ai_1_A1_B1_sg13g2_nand2_1_Y_A_sg13g2_nand3_1_Y_A_sg13g2_a21oi_1_B1/Y
+ sg13g2_o21ai_1
Xcarry_flag_sg13g2_o21ai_1_A1_B1_sg13g2_nand2_1_Y_B_sg13g2_a21oi_1_Y_A2_sg13g2_a21oi_1_Y_B1_sg13g2_o21ai_1_B1_Y_sg13g2_a221oi_1_B1_1_Y_sg13g2_or4_1_C
+ carry_flag_sg13g2_o21ai_1_A1_B1_sg13g2_nand2_1_Y_B_sg13g2_a21oi_1_Y_A2_sg13g2_a21oi_1_Y_B1_sg13g2_o21ai_1_B1_Y_sg13g2_a221oi_1_B1_1_Y_sg13g2_or4_1_C/X
+ carry_flag_sg13g2_o21ai_1_A1_B1_sg13g2_nand2_1_Y_B_sg13g2_a21oi_1_Y_A2_sg13g2_a21oi_1_Y_B1_sg13g2_o21ai_1_B1_Y_sg13g2_a221oi_1_B1_1/Y
+ carry_flag_sg13g2_o21ai_1_A1_B1_sg13g2_nand2_1_Y_B_sg13g2_a21oi_1_Y_A2_sg13g2_a21oi_1_Y_B1_sg13g2_o21ai_1_B1_Y_sg13g2_a221oi_1_B1_1_Y_sg13g2_or4_1_C/D
+ VDD VSS carry_flag_sg13g2_o21ai_1_A1_B1_sg13g2_nand2_1_Y_B_sg13g2_a21oi_1_Y_A2_sg13g2_a21oi_1_Y_B1_sg13g2_o21ai_1_B1_Y_sg13g2_a221oi_1_B1_1_Y_sg13g2_or4_1_C/A
+ carry_flag_sg13g2_o21ai_1_A1_B1_sg13g2_nand2_1_Y_B_sg13g2_a21oi_1_Y_A2_sg13g2_a21oi_1_Y_B1_sg13g2_o21ai_1_B1_Y_sg13g2_a221oi_1_B1_1_Y_sg13g2_or4_1_C/B
+ sg13g2_or4_1
Xuo_out_sg13g2_dfrbpq_1_Q_3_D_sg13g2_o21ai_1_Y_B1_sg13g2_nand2_1_Y_B_sg13g2_a22oi_1_Y_A1_sg13g2_a221oi_1_Y_C1_sg13g2_or4_1_X_B_sg13g2_o21ai_1_Y_A2_sg13g2_o21ai_1_Y
+ VSS VDD uo_out_sg13g2_dfrbpq_1_Q_3_D_sg13g2_o21ai_1_Y_B1_sg13g2_nand2_1_Y_B_sg13g2_a22oi_1_Y_A1_sg13g2_a221oi_1_Y_C1_sg13g2_or4_1_X_B_sg13g2_o21ai_1_Y/A2
+ carry_flag_sg13g2_o21ai_1_A1_B1_sg13g2_nand2_1_Y_A_sg13g2_nand3_1_Y_B_sg13g2_nand3_1_C_A_sg13g2_o21ai_1_B1/A1
+ carry_flag_sg13g2_o21ai_1_A1_B1_sg13g2_nand2_1_Y_A_sg13g2_nand3_1_Y_B_sg13g2_nand3_1_Y_A_sg13g2_nor3_1_A/C
+ carry_flag_sg13g2_o21ai_1_A1_B1_sg13g2_nand2_1_Y_A_sg13g2_nand3_1_Y_B_sg13g2_nand3_1_Y_A_sg13g2_nor3_1_A/B
+ sg13g2_o21ai_1
Xmisr\[4\]_sg13g2_inv_1_A_Y_sg13g2_xnor2_1_A_B_sg13g2_o21ai_1_Y_A1_sg13g2_a21oi_1_Y_A2_sg13g2_a21oi_1_Y_A2_sg13g2_mux2_1_X_S_sg13g2_nand2_1_Y_B_sg13g2_nand3_1_Y
+ VDD misr\[4\]_sg13g2_inv_1_A_Y_sg13g2_xnor2_1_A_B_sg13g2_o21ai_1_Y_A1_sg13g2_a21oi_1_Y_A2_sg13g2_a21oi_1_Y_A2_sg13g2_mux2_1_X_S_sg13g2_nand2_1_Y/B
+ misr\[1\]_sg13g2_inv_1_A_Y_sg13g2_xnor2_1_A_B_sg13g2_o21ai_1_Y_A2_sg13g2_nand3_1_Y_C_sg13g2_a22oi_1_Y_B1_sg13g2_and2_1_X_A_sg13g2_or3_1_X/A
+ misr\[4\]_sg13g2_inv_1_A_Y_sg13g2_xnor2_1_A_B_sg13g2_o21ai_1_Y_B1_sg13g2_or2_1_X_A_sg13g2_nand3_1_Y_C_sg13g2_a21oi_1_Y_B1_sg13g2_a221oi_1_Y/A2
+ bist_a\[7\]_sg13g2_dfrbpq_1_Q_D_sg13g2_o21ai_1_Y_A1_sg13g2_nand2_1_A_Y_sg13g2_a221oi_1_B2_Y_sg13g2_o21ai_1_B1_A1_sg13g2_nor3_1_Y/A
+ VSS sg13g2_nand3_1
Xscan_reg\[20\]_sg13g2_dfrbpq_1_Q_D_sg13g2_a221oi_1_Y scan_reg\[21\]_sg13g2_nor2_1_A/Y
+ scan_reg\[20\]_sg13g2_dfrbpq_1_Q/D scan_out_sg13g2_a22oi_1_A1/A2 scan_reg\[20\]_sg13g2_inv_1_A/Y
+ uo_out_sg13g2_dfrbpq_1_Q_3_D_sg13g2_o21ai_1_Y/A1 VDD ui_in[3] VSS sg13g2_a221oi_1
Xscan_reg\[42\]_sg13g2_inv_1_A scan_reg\[42\]_sg13g2_inv_1_A/Y scan_reg\[42\]_sg13g2_inv_1_A/A
+ VSS VDD sg13g2_inv_1
Xbist_a\[7\]_sg13g2_dfrbpq_1_Q_D_sg13g2_o21ai_1_Y_A1_sg13g2_nand2_1_A_Y_sg13g2_a221oi_1_B2
+ bist_a\[7\]_sg13g2_dfrbpq_1_Q_D_sg13g2_o21ai_1_Y_A1_sg13g2_nand2_1_A_Y_sg13g2_a221oi_1_B2/C1
+ bist_a\[7\]_sg13g2_dfrbpq_1_Q_D_sg13g2_o21ai_1_Y_A1_sg13g2_nand2_1_A_Y_sg13g2_a221oi_1_B2/Y
+ bist_a\[7\]_sg13g2_dfrbpq_1_Q_D_sg13g2_o21ai_1_Y_A1_sg13g2_nand2_1_A/Y bist_a\[7\]_sg13g2_dfrbpq_1_Q_D_sg13g2_o21ai_1_Y_A1_sg13g2_nand2_1_A_Y_sg13g2_a221oi_1_B2/B1
+ bist_a\[7\]_sg13g2_dfrbpq_1_Q_D_sg13g2_o21ai_1_Y_A1_sg13g2_nand2_1_A_Y_sg13g2_a221oi_1_B2/A2
+ VDD bist_a\[7\]_sg13g2_dfrbpq_1_Q_D_sg13g2_o21ai_1_Y_A1_sg13g2_nand2_1_A_Y_sg13g2_a221oi_1_B2/A1
+ VSS sg13g2_a221oi_1
Xbist_a\[7\]_sg13g2_dfrbpq_1_Q_D_sg13g2_o21ai_1_Y_A1_sg13g2_nand2_1_A_Y_sg13g2_a221oi_1_A1
+ bist_a\[7\]_sg13g2_dfrbpq_1_Q_D_sg13g2_o21ai_1_Y_A1_sg13g2_nand2_1_A_Y_sg13g2_a221oi_1_A1/C1
+ bist_a\[7\]_sg13g2_dfrbpq_1_Q_D_sg13g2_o21ai_1_Y_A1_sg13g2_nand2_1_A_Y_sg13g2_a221oi_1_A1/Y
+ lfsr\[6\]_sg13g2_mux2_1_A1/A0 bist_a\[7\]_sg13g2_dfrbpq_1_Q_D_sg13g2_o21ai_1_Y_A1_sg13g2_nand2_1_A_Y_sg13g2_a221oi_1_A1/B1
+ bist_a\[7\]_sg13g2_dfrbpq_1_Q_D_sg13g2_o21ai_1_Y_A1_sg13g2_nand2_1_A_Y_sg13g2_a221oi_1_A1/A2
+ VDD bist_a\[7\]_sg13g2_dfrbpq_1_Q_D_sg13g2_o21ai_1_Y_A1_sg13g2_nand2_1_A/Y VSS sg13g2_a221oi_1
Xuo_out_sg13g2_dfrbpq_1_Q_D_sg13g2_a21oi_1_Y_B1_sg13g2_a21oi_1_Y VDD VSS uo_out_sg13g2_dfrbpq_1_Q_D_sg13g2_a21oi_1_Y_B1_sg13g2_a21oi_1_Y/A2
+ uo_out_sg13g2_dfrbpq_1_Q_D_sg13g2_a21oi_1_Y_B1_sg13g2_a21oi_1_Y/A1 zero_flag_sg13g2_nand2_1_A/B
+ uo_out_sg13g2_dfrbpq_1_Q_D_sg13g2_a21oi_1_Y/B1 sg13g2_a21oi_1
Xscan_reg\[29\]_sg13g2_a22oi_1_B2 scan_reg\[29\]_sg13g2_a22oi_1_B2/Y zero_flag_sg13g2_nand2_1_A/A
+ VDD scan_out_sg13g2_a22oi_1_A1/B1 ui_in[3] VSS scan_reg\[29\]_sg13g2_inv_1_A/A sg13g2_a22oi_1
Xbist_pattern_count\[4\]_sg13g2_dfrbpq_1_Q VDD bist_pattern_count\[4\]_sg13g2_dfrbpq_1_Q/D
+ bist_pattern_count\[4\]_sg13g2_and2_1_A/A clkbuf_5_2__f_clk/X VSS rst_n sg13g2_dfrbpq_1
Xscan_reg\[2\]_sg13g2_inv_1_A scan_reg\[2\]_sg13g2_inv_1_A/Y scan_reg\[2\]_sg13g2_inv_1_A/A
+ VSS VDD sg13g2_inv_1
Xuo_out_sg13g2_dfrbpq_1_Q_5_D_sg13g2_a21oi_1_Y_A2_sg13g2_o21ai_1_Y_B1_sg13g2_or2_1_X_B_sg13g2_nand2_1_Y_B_sg13g2_a22oi_1_Y
+ uo_out_sg13g2_dfrbpq_1_Q_5_D_sg13g2_a21oi_1_Y_A2_sg13g2_o21ai_1_Y_B1_sg13g2_or2_1_X_B_sg13g2_nand2_1_Y/B
+ uo_out_sg13g2_dfrbpq_1_Q_6_D_sg13g2_a21oi_1_Y_A2_sg13g2_a21o_1_X_A2_sg13g2_and2_1_X_B_sg13g2_a22oi_1_Y/A2
+ VDD uo_out_sg13g2_dfrbpq_1_Q_5_D_sg13g2_a21oi_1_Y_A2_sg13g2_o21ai_1_Y_B1_sg13g2_or2_1_X_B_sg13g2_nand2_1_Y_B_sg13g2_a22oi_1_Y/B1
+ serial_b\[5\]_sg13g2_nand2b_1_B/B VSS uo_out_sg13g2_dfrbpq_1_Q_5_D_sg13g2_a21oi_1_Y_A2_sg13g2_o21ai_1_Y_B1_sg13g2_or2_1_X_B_sg13g2_nand2_1_Y_B_sg13g2_a22oi_1_Y/B2
+ sg13g2_a22oi_1
Xlfsr\[5\]_sg13g2_dfrbpq_1_Q_D_sg13g2_inv_1_Y_A_sg13g2_a22oi_1_Y lfsr\[5\]_sg13g2_dfrbpq_1_Q_D_sg13g2_inv_1_Y/A
+ lfsr\[7\]_sg13g2_a22oi_1_A1/A2 VDD lfsr\[7\]_sg13g2_a22oi_1_A1/B1 lfsr\[5\]_sg13g2_dfrbpq_1_Q/Q
+ VSS lfsr\[4\]_sg13g2_dfrbpq_1_Q/Q sg13g2_a22oi_1
Xbist_a\[7\]_sg13g2_dfrbpq_1_Q_D_sg13g2_o21ai_1_Y_A1_sg13g2_nand2_1_A_B_sg13g2_inv_1_Y_A_sg13g2_nand2b_1_B
+ VSS bist_a\[4\]_sg13g2_dfrbpq_1_Q/Q bist_a\[7\]_sg13g2_dfrbpq_1_Q_D_sg13g2_o21ai_1_Y_A1_sg13g2_o21ai_1_A1_B1_sg13g2_nand4_1_C/D
+ bist_a\[7\]_sg13g2_dfrbpq_1_Q_D_sg13g2_o21ai_1_Y_A1_sg13g2_nand2_1_A_B_sg13g2_inv_1_Y/A
+ VDD sg13g2_nand2b_1
Xoverflow_flag_sg13g2_dfrbpq_1_Q_D_sg13g2_inv_1_Y_A_sg13g2_o21ai_1_Y_B1_sg13g2_nand3_1_Y_A_sg13g2_nand2_1_Y_B_sg13g2_a21oi_1_Y_A2_sg13g2_o21ai_1_Y_B1_sg13g2_a22oi_1_B2
+ overflow_flag_sg13g2_dfrbpq_1_Q_D_sg13g2_inv_1_Y_A_sg13g2_o21ai_1_Y_B1_sg13g2_nand3_1_Y_A_sg13g2_nand2_1_Y_B_sg13g2_a21oi_1_Y_A2_sg13g2_o21ai_1_Y_B1_sg13g2_a22oi_1_B2/Y
+ serial_opcode\[2\]_sg13g2_nor3_1_A/Y VDD uo_out_sg13g2_dfrbpq_1_Q_6_D_sg13g2_a21oi_1_Y_A2_sg13g2_a21o_1_X_A2_sg13g2_and2_1_X_A_sg13g2_a221oi_1_Y_C1_sg13g2_nand3_1_Y_C_sg13g2_a221oi_1_Y/A2
+ overflow_flag_sg13g2_dfrbpq_1_Q_D_sg13g2_inv_1_Y_A_sg13g2_o21ai_1_Y_B1_sg13g2_nand3_1_Y_A_sg13g2_nand2_1_Y_B_sg13g2_a21oi_1_Y_A2_sg13g2_o21ai_1_Y_B1_sg13g2_and2_1_X/B
+ VSS overflow_flag_sg13g2_dfrbpq_1_Q_D_sg13g2_inv_1_Y_A_sg13g2_o21ai_1_Y_B1_sg13g2_nand3_1_Y_A_sg13g2_nand2_1_Y_B_sg13g2_a21oi_1_Y_A2_sg13g2_o21ai_1_Y/B1
+ sg13g2_a22oi_1
Xmisr\[0\]_sg13g2_dfrbpq_1_Q_D_sg13g2_a22oi_1_Y_B2_sg13g2_o21ai_1_Y_A2_sg13g2_a21oi_1_Y_A2_sg13g2_nor2b_1_Y_A_sg13g2_nor4_1_Y_C_sg13g2_nand2b_1_Y
+ VSS bist_a\[7\]_sg13g2_dfrbpq_1_Q_D_sg13g2_o21ai_1_Y_A1_sg13g2_nand2_1_A_Y_sg13g2_a221oi_1_A1_Y_sg13g2_o21ai_1_B1_A1_sg13g2_xnor2_1_Y/B
+ misr\[0\]_sg13g2_dfrbpq_1_Q_D_sg13g2_a22oi_1_Y_B2_sg13g2_o21ai_1_Y_A2_sg13g2_a21oi_1_Y_A2_sg13g2_nor2b_1_Y_A_sg13g2_nor4_1_Y/C
+ bist_a\[7\]_sg13g2_dfrbpq_1_Q_D_sg13g2_o21ai_1_Y_A1_sg13g2_nand2_1_A_Y_sg13g2_a221oi_1_B2_Y_sg13g2_o21ai_1_B1_A1_sg13g2_nor3_1_Y/A
+ VDD sg13g2_nand2b_1
Xoverflow_flag_sg13g2_dfrbpq_1_Q_D_sg13g2_inv_1_Y_A_sg13g2_o21ai_1_Y_B1_sg13g2_nand3_1_Y_A_sg13g2_nand2_1_Y
+ overflow_flag_sg13g2_dfrbpq_1_Q_D_sg13g2_inv_1_Y_A_sg13g2_o21ai_1_Y_B1_sg13g2_nand3_1_Y/A
+ VDD carry_flag_sg13g2_o21ai_1_A1_B1_sg13g2_nand2_1_Y_B_sg13g2_a21oi_1_Y/A1 VSS overflow_flag_sg13g2_dfrbpq_1_Q_D_sg13g2_inv_1_Y_A_sg13g2_o21ai_1_Y_B1_sg13g2_nand3_1_Y_A_sg13g2_nand2_1_Y/B
+ sg13g2_nand2_1
Xbist_a\[7\]_sg13g2_dfrbpq_1_Q_D_sg13g2_o21ai_1_Y_A1_sg13g2_nand2_1_A_Y_sg13g2_a221oi_1_A1_A2_sg13g2_nand3_1_Y_C_sg13g2_nand3_1_Y
+ VDD bist_a\[7\]_sg13g2_dfrbpq_1_Q_D_sg13g2_o21ai_1_Y_A1_sg13g2_nand2_1_A_Y_sg13g2_a221oi_1_A1_A2_sg13g2_nand3_1_Y/C
+ bist_a\[0\]_sg13g2_dfrbpq_1_Q/Q bist_a\[7\]_sg13g2_dfrbpq_1_Q_D_sg13g2_o21ai_1_Y_A1_sg13g2_nand2_1_A_Y_sg13g2_a221oi_1_A1_A2_sg13g2_nand3_1_Y_C_sg13g2_nand3_1_Y/C
+ bist_a\[1\]_sg13g2_dfrbpq_1_Q/Q VSS sg13g2_nand3_1
Xmisr\[6\]_sg13g2_dfrbpq_1_Q VDD misr\[6\]_sg13g2_dfrbpq_1_Q/D misr\[6\]_sg13g2_dfrbpq_1_Q/Q
+ clkbuf_5_12__f_clk/X VSS rst_n sg13g2_dfrbpq_1
Xmisr\[7\]_sg13g2_dfrbpq_1_Q_D_sg13g2_a22oi_1_Y_B2_sg13g2_o21ai_1_Y VSS VDD misr\[7\]_sg13g2_dfrbpq_1_Q_D_sg13g2_a22oi_1_Y/B2
+ misr\[7\]_sg13g2_dfrbpq_1_Q_D_sg13g2_a22oi_1_Y_B2_sg13g2_o21ai_1_Y/B1 misr\[7\]_sg13g2_dfrbpq_1_Q_D_sg13g2_a22oi_1_Y_B2_sg13g2_o21ai_1_Y/A2
+ misr\[6\]_sg13g2_dfrbpq_1_Q/Q sg13g2_o21ai_1
Xserial_opcode\[2\]_sg13g2_dfrbpq_1_Q VDD serial_opcode\[2\]_sg13g2_dfrbpq_1_Q/D serial_opcode\[2\]_sg13g2_inv_1_A/A
+ clkbuf_5_22__f_clk/X VSS rst_n sg13g2_dfrbpq_1
Xuo_out_sg13g2_dfrbpq_1_Q_1_D_sg13g2_a21oi_1_Y_A2_sg13g2_o21ai_1_Y_A2_sg13g2_o21ai_1_Y_A2_sg13g2_and2_1_X
+ uo_out_sg13g2_dfrbpq_1_Q_1_D_sg13g2_a21oi_1_Y_A2_sg13g2_o21ai_1_Y_A2_sg13g2_o21ai_1_Y/A2
+ VSS VDD uo_out_sg13g2_dfrbpq_1_Q_1_D_sg13g2_a21oi_1_Y_A2_sg13g2_o21ai_1_Y_A2_sg13g2_o21ai_1_Y_A2_sg13g2_and2_1_X/B
+ uo_out_sg13g2_dfrbpq_1_Q_D_sg13g2_a21oi_1_Y_B1_sg13g2_a21oi_1_Y_A1_sg13g2_nand3_1_Y_C_sg13g2_nand4_1_Y/D
+ sg13g2_and2_1
Xbist_a\[3\]_sg13g2_dfrbpq_1_Q_D_sg13g2_o21ai_1_Y_A1_sg13g2_inv_1_Y bist_a\[3\]_sg13g2_dfrbpq_1_Q_D_sg13g2_o21ai_1_Y/A1
+ bist_a\[7\]_sg13g2_or2_1_A/B VSS VDD sg13g2_inv_1
Xbist_pattern_count\[6\]_sg13g2_dfrbpq_1_Q_D_sg13g2_nor3_1_Y_B_sg13g2_nor2_1_Y bist_pattern_count\[7\]_sg13g2_dfrbpq_1_Q/Q
+ VDD bist_pattern_count\[6\]_sg13g2_dfrbpq_1_Q_D_sg13g2_nor3_1_Y/B VSS bist_pattern_count\[7\]_sg13g2_dfrbpq_1_Q_D_sg13g2_a21oi_1_Y/A2
+ sg13g2_nor2_1
Xoperand_a\[0\]_sg13g2_dfrbpq_1_Q_D_sg13g2_a21oi_1_Y VDD VSS ui_in[2] serial_a\[0\]_sg13g2_dfrbpq_1_Q_D_sg13g2_o21ai_1_Y/A1
+ operand_a\[0\]_sg13g2_nor2_1_A/Y operand_a\[0\]_sg13g2_dfrbpq_1_Q/D sg13g2_a21oi_1
Xbist_fault_sg13g2_dfrbpq_1_Q_D_sg13g2_nor3_1_Y_A_sg13g2_and2_1_X bist_fault_sg13g2_dfrbpq_1_Q_D_sg13g2_nor3_1_Y/A
+ VSS VDD bist_state\[1\]_sg13g2_a21oi_1_A1/B1 bist_state\[1\]_sg13g2_inv_1_A/Y sg13g2_and2_1
Xscan_reg\[7\]_sg13g2_inv_1_A scan_reg\[7\]_sg13g2_inv_1_A/Y scan_reg\[7\]_sg13g2_inv_1_A/A
+ VSS VDD sg13g2_inv_1
Xscan_reg\[33\]_sg13g2_inv_1_A scan_reg\[33\]_sg13g2_inv_1_A/Y scan_reg\[33\]_sg13g2_inv_1_A/A
+ VSS VDD sg13g2_inv_1
Xbist_a\[7\]_sg13g2_dfrbpq_1_Q_D_sg13g2_o21ai_1_Y_A1_sg13g2_nand2_1_A_Y_sg13g2_a221oi_1_B2_B1_sg13g2_nand2_1_Y_A_sg13g2_nor2_1_B
+ bist_a\[3\]_sg13g2_dfrbpq_1_Q_D_sg13g2_o21ai_1_Y/A1 VDD bist_a\[7\]_sg13g2_dfrbpq_1_Q_D_sg13g2_o21ai_1_Y_A1_sg13g2_nand2_1_A_Y_sg13g2_a221oi_1_A1/C1
+ VSS bist_a\[7\]_sg13g2_dfrbpq_1_Q_D_sg13g2_o21ai_1_Y_A1_sg13g2_nand2_1_A_Y_sg13g2_a221oi_1_B2_B1_sg13g2_nand2_1_Y/A
+ sg13g2_nor2_1
Xcycle_counter\[0\]_sg13g2_dfrbpq_1_Q_D_sg13g2_inv_1_Y cycle_counter\[0\]_sg13g2_dfrbpq_1_Q/D
+ cycle_counter\[0\]_sg13g2_dfrbpq_1_Q/Q VSS VDD sg13g2_inv_1
Xmisr\[7\]_sg13g2_dfrbpq_1_Q_D_sg13g2_a22oi_1_Y misr\[7\]_sg13g2_dfrbpq_1_Q/D misr\[7\]_sg13g2_dfrbpq_1_Q_D_sg13g2_a22oi_1_Y/A2
+ VDD bist_state\[3\]_sg13g2_nor2_1_A/Y misr\[7\]_sg13g2_dfrbpq_1_Q_D_sg13g2_a22oi_1_Y/A1
+ VSS misr\[7\]_sg13g2_dfrbpq_1_Q_D_sg13g2_a22oi_1_Y/B2 sg13g2_a22oi_1
Xlfsr\[5\]_sg13g2_dfrbpq_1_Q VDD lfsr\[5\]_sg13g2_dfrbpq_1_Q/D lfsr\[5\]_sg13g2_dfrbpq_1_Q/Q
+ clkbuf_5_0__f_clk/X VSS rst_n sg13g2_dfrbpq_1
Xfault_counter\[1\]_sg13g2_dfrbpq_1_Q_D_sg13g2_xor2_1_X_B_sg13g2_and2_1_B fault_counter\[2\]_sg13g2_dfrbpq_1_Q_D_sg13g2_xnor2_1_Y/B
+ VSS VDD fault_counter\[1\]_sg13g2_dfrbpq_1_Q_D_sg13g2_xor2_1_X/B fault_counter\[1\]_sg13g2_dfrbpq_1_Q/Q
+ sg13g2_and2_1
Xcarry_flag_sg13g2_o21ai_1_A1_B1_sg13g2_nand2_1_Y_B_sg13g2_a21oi_1_Y_A2_sg13g2_a21oi_1_Y_B1_sg13g2_o21ai_1_B1_Y_sg13g2_a221oi_1_B1_1_B2_sg13g2_xnor2_1_Y
+ carry_flag_sg13g2_o21ai_1_A1_B1_sg13g2_nand2_1_Y_B_sg13g2_a21oi_1_Y_A2_sg13g2_a21oi_1_Y_B1_sg13g2_o21ai_1_B1_Y_sg13g2_a221oi_1_B1_1/B2
+ carry_flag_sg13g2_o21ai_1_A1_B1_sg13g2_nand2_1_Y_B_sg13g2_a21oi_1_Y_A2_sg13g2_a21oi_1_Y_B1_sg13g2_o21ai_1_B1_Y_sg13g2_a221oi_1_B1_1_B2_sg13g2_xnor2_1_Y/B
+ VDD serial_b\[2\]_sg13g2_xor2_1_A/X VSS sg13g2_xnor2_1
Xscan_reg\[18\]_sg13g2_dfrbpq_1_Q VDD scan_reg\[18\]_sg13g2_dfrbpq_1_Q/D scan_reg\[18\]_sg13g2_inv_1_A/A
+ clkbuf_5_29__f_clk/X VSS rst_n sg13g2_dfrbpq_1
Xclkbuf_4_14_0_clk clkbuf_4_14_0_clk/X VSS clkbuf_0_clk/X VDD sg13g2_buf_4
Xscan_reg\[6\]_sg13g2_o21ai_1_A1_1 VSS VDD scan_reg\[6\]_sg13g2_o21ai_1_A1_1/Y scan_reg\[6\]_sg13g2_o21ai_1_A1_1/B1
+ scan_reg\[41\]_sg13g2_nor2_1_A/B scan_reg\[6\]_sg13g2_dfrbpq_1_Q/Q sg13g2_o21ai_1
Xscan_reg\[38\]_sg13g2_dfrbpq_1_Q VDD scan_reg\[38\]_sg13g2_dfrbpq_1_Q/D scan_reg\[38\]_sg13g2_inv_1_A/A
+ clkbuf_5_12__f_clk/X VSS rst_n sg13g2_dfrbpq_1
Xnegative_flag_sg13g2_dfrbpq_1_Q_D_sg13g2_a21oi_1_Y_A2_sg13g2_o21ai_1_Y_A2_sg13g2_o21ai_1_Y
+ VSS VDD negative_flag_sg13g2_dfrbpq_1_Q_D_sg13g2_a21oi_1_Y_A2_sg13g2_o21ai_1_Y/A2
+ negative_flag_sg13g2_dfrbpq_1_Q_D_sg13g2_a21oi_1_Y_A2_sg13g2_o21ai_1_Y_A2_sg13g2_o21ai_1_Y/B1
+ uo_out_sg13g2_dfrbpq_1_Q_4_D_sg13g2_a21oi_1_Y_A2_sg13g2_a21o_1_X_B1_sg13g2_and2_1_X/B
+ negative_flag_sg13g2_dfrbpq_1_Q_D_sg13g2_a21oi_1_Y_A2_sg13g2_o21ai_1_Y_A2_sg13g2_o21ai_1_Y/A1
+ sg13g2_o21ai_1
Xbist_fault_sg13g2_nor2_1_B_Y_sg13g2_o21ai_1_A2_B1_sg13g2_nand3b_1_Y_B_sg13g2_nand2_1_B_Y_sg13g2_nand2_1_B
+ misr\[7\]_sg13g2_dfrbpq_1_Q_D_sg13g2_a22oi_1_Y/A2 VDD bist_fault_sg13g2_o21ai_1_A2/Y
+ VSS bist_fault_sg13g2_nor2_1_B_Y_sg13g2_o21ai_1_A2_B1_sg13g2_nand3b_1_Y_B_sg13g2_nand2_1_B/Y
+ sg13g2_nand2_1
Xscan_reg\[38\]_sg13g2_inv_1_A scan_reg\[38\]_sg13g2_inv_1_A/Y scan_reg\[38\]_sg13g2_inv_1_A/A
+ VSS VDD sg13g2_inv_1
Xscan_reg\[42\]_sg13g2_dfrbpq_1_Q_D_sg13g2_a221oi_1_Y_A1_sg13g2_inv_1_Y scan_reg\[42\]_sg13g2_dfrbpq_1_Q_D_sg13g2_a221oi_1_Y/A1
+ fault_counter\[0\]_sg13g2_dfrbpq_1_Q/Q VSS VDD sg13g2_inv_1
Xoverflow_flag_sg13g2_dfrbpq_1_Q_D_sg13g2_inv_1_Y_A_sg13g2_o21ai_1_Y_B1_sg13g2_nand3_1_Y_C_sg13g2_a21oi_1_Y_A1_sg13g2_o21ai_1_A2_B1_sg13g2_o21ai_1_A1_Y_sg13g2_nor2_1_B_A_sg13g2_nand3_1_Y_C_sg13g2_a21oi_1_Y_B1_sg13g2_nor2_1_Y
+ serial_b\[2\]_sg13g2_xor2_1_A/B VDD overflow_flag_sg13g2_dfrbpq_1_Q_D_sg13g2_inv_1_Y_A_sg13g2_o21ai_1_Y_B1_sg13g2_nand3_1_Y_C_sg13g2_a21oi_1_Y_A1_sg13g2_o21ai_1_A2_B1_sg13g2_o21ai_1_A1_Y_sg13g2_nor2_1_B_A_sg13g2_nand3_1_Y_C_sg13g2_a21oi_1_Y/B1
+ VSS overflow_flag_sg13g2_dfrbpq_1_Q_D_sg13g2_inv_1_Y_A_sg13g2_o21ai_1_Y_B1_sg13g2_nand3_1_Y_A_sg13g2_and4_1_A_B_sg13g2_or2_1_X/B
+ sg13g2_nor2_1
Xclkbuf_5_28__f_clk clkbuf_5_28__f_clk/X VSS clkbuf_4_14_0_clk/X VDD sg13g2_buf_4
Xlfsr\[7\]_sg13g2_xnor2_1_B lfsr\[7\]_sg13g2_xnor2_1_B/Y lfsr\[7\]_sg13g2_xnor2_1_B/B
+ VDD lfsr\[7\]_sg13g2_xnor2_1_B/A VSS sg13g2_xnor2_1
Xuo_out_sg13g2_dfrbpq_1_Q_6_D_sg13g2_a21oi_1_Y_A2_sg13g2_a21o_1_X_A2_sg13g2_and2_1_X_A_sg13g2_a221oi_1_Y_B2_sg13g2_and2_1_X_B_sg13g2_o21ai_1_Y_A1_sg13g2_or3_1_B
+ VDD VSS uo_out_sg13g2_dfrbpq_1_Q_6_D_sg13g2_a21oi_1_Y_A2_sg13g2_a21o_1_X_A2_sg13g2_and2_1_X_A_sg13g2_a221oi_1_Y_B2_sg13g2_and2_1_X_B_sg13g2_o21ai_1_Y/A2
+ uo_out_sg13g2_dfrbpq_1_Q_6_D_sg13g2_a21oi_1_Y_A2_sg13g2_a21o_1_X_A2_sg13g2_and2_1_X_A_sg13g2_a221oi_1_Y_B2_sg13g2_and2_1_X_B_sg13g2_o21ai_1_Y/A1
+ uo_out_sg13g2_dfrbpq_1_Q_6_D_sg13g2_a21oi_1_Y_A2_sg13g2_a21o_1_X_A2_sg13g2_and2_1_X_A_sg13g2_a221oi_1_Y_B2_sg13g2_and2_1_X_B_sg13g2_o21ai_1_Y/B1
+ uo_out_sg13g2_dfrbpq_1_Q_6_D_sg13g2_a21oi_1_Y_A2_sg13g2_a21o_1_X_A2_sg13g2_and2_1_X_A_sg13g2_a221oi_1_Y_B2_sg13g2_and2_1_X/A
+ sg13g2_or3_1
Xscan_reg\[28\]_sg13g2_dfrbpq_1_Q_D_sg13g2_o21ai_1_Y VSS VDD scan_reg\[28\]_sg13g2_dfrbpq_1_Q/D
+ scan_reg\[29\]_sg13g2_a22oi_1_B2/Y scan_reg\[28\]_sg13g2_nand2b_1_B/Y ui_in[6] sg13g2_o21ai_1
Xbist_pattern_count\[6\]_sg13g2_nand3_1_C_Y_sg13g2_nor2_1_B bist_pattern_count\[3\]_sg13g2_nand4_1_D/Y
+ VDD bist_pattern_count\[6\]_sg13g2_nand3_1_C_Y_sg13g2_nor2_1_B/Y VSS bist_pattern_count\[6\]_sg13g2_nand3_1_C/Y
+ sg13g2_nor2_1
Xscan_reg\[24\]_sg13g2_inv_1_A scan_reg\[24\]_sg13g2_inv_1_A/Y scan_reg\[24\]_sg13g2_inv_1_A/A
+ VSS VDD sg13g2_inv_1
Xuo_out_sg13g2_dfrbpq_1_Q_4_D_sg13g2_a21oi_1_Y_A2_sg13g2_a21o_1_X_A1_sg13g2_a22oi_1_Y
+ uo_out_sg13g2_dfrbpq_1_Q_4_D_sg13g2_a21oi_1_Y_A2_sg13g2_a21o_1_X/A1 uo_out_sg13g2_dfrbpq_1_Q_4_D_sg13g2_a21oi_1_Y_A2_sg13g2_a21o_1_X_B1_sg13g2_and2_1_X/B
+ VDD uo_out_sg13g2_dfrbpq_1_Q_5_D_sg13g2_a21oi_1_Y_A2_sg13g2_o21ai_1_Y_B1_sg13g2_or2_1_X/B
+ uo_out_sg13g2_dfrbpq_1_Q_5_D_sg13g2_a21oi_1_Y_A2_sg13g2_o21ai_1_Y_A2_sg13g2_mux2_1_X/A0
+ VSS uio_in[1] sg13g2_a22oi_1
Xmisr\[2\]_sg13g2_dfrbpq_1_Q_D_sg13g2_o21ai_1_Y_B1_sg13g2_nand2_1_Y misr\[2\]_sg13g2_dfrbpq_1_Q_D_sg13g2_o21ai_1_Y/B1
+ VDD misr\[2\]_sg13g2_dfrbpq_1_Q/Q VSS misr\[7\]_sg13g2_dfrbpq_1_Q_D_sg13g2_a22oi_1_Y/A2
+ sg13g2_nand2_1
Xbist_pattern_count\[7\]_sg13g2_dfrbpq_1_Q_D_sg13g2_a21oi_1_Y_A2_sg13g2_nand2b_1_Y
+ VSS lfsr\[7\]_sg13g2_a22oi_1_A1/A2 bist_pattern_count\[7\]_sg13g2_dfrbpq_1_Q_D_sg13g2_a21oi_1_Y/A2
+ bist_pattern_count\[6\]_sg13g2_nand3_1_C_Y_sg13g2_nor2_1_B/Y VDD sg13g2_nand2b_1
Xbist_pattern_count\[1\]_sg13g2_dfrbpq_1_Q_D_sg13g2_nor3_1_Y_C_sg13g2_a21oi_1_Y VDD
+ VSS bist_pattern_count\[1\]_sg13g2_and3_1_A/C bist_pattern_count\[1\]_sg13g2_and3_1_A/B
+ bist_pattern_count\[1\]_sg13g2_and3_1_A/A bist_pattern_count\[1\]_sg13g2_dfrbpq_1_Q_D_sg13g2_nor3_1_Y/C
+ sg13g2_a21oi_1
Xoperation\[1\]_sg13g2_mux2_1_A0 operation\[1\]_sg13g2_mux2_1_A0/A1 operation\[1\]_sg13g2_mux2_1_A0/X
+ ui_in[2] VDD VSS operation\[1\]_sg13g2_mux2_1_A0/A0 sg13g2_mux2_1
Xclkbuf_5_11__f_clk clkbuf_5_11__f_clk/X VSS clkbuf_4_5_0_clk/X VDD sg13g2_buf_4
Xoperand_a\[7\]_sg13g2_mux2_1_A0 serial_a\[7\]_sg13g2_dfrbpq_1_Q/Q operand_a\[7\]_sg13g2_mux2_1_A0/X
+ ui_in[2] VDD VSS operand_a\[7\]_sg13g2_mux2_1_A0/A0 sg13g2_mux2_1
Xuo_out_sg13g2_dfrbpq_1_Q_5_D_sg13g2_a21oi_1_Y_A2_sg13g2_o21ai_1_Y_B1_sg13g2_or2_1_X_B_sg13g2_nand2_1_Y_A_sg13g2_a221oi_1_Y_B2_sg13g2_xor2_1_X_A_sg13g2_nand2_1_Y_A_sg13g2_nand3_1_B_Y_sg13g2_and3_1_C
+ carry_flag_sg13g2_o21ai_1_A1_B1_sg13g2_nand2_1_Y_A_sg13g2_nand3_1_Y_B_sg13g2_nand3_1_Y_A_sg13g2_nor3_1_A/C
+ serial_b\[5\]_sg13g2_nand2b_1_B/Y VDD VSS uo_out_sg13g2_dfrbpq_1_Q_5_D_sg13g2_a21oi_1_Y_A2_sg13g2_o21ai_1_Y_B1_sg13g2_or2_1_X_B_sg13g2_nand2_1_Y_A_sg13g2_a221oi_1_Y_B2_sg13g2_xor2_1_X_A_sg13g2_nand2_1_Y_A_sg13g2_nand3_1_B/Y
+ carry_flag_sg13g2_o21ai_1_A1_B1_sg13g2_nand2_1_Y_A_sg13g2_nand3_1_Y_B_sg13g2_nand3_1_C_Y_sg13g2_o21ai_1_B1_A2_sg13g2_nor3_1_Y_C_sg13g2_nor4_1_Y_D_sg13g2_nand2_1_Y/A
+ sg13g2_and3_1
Xoverflow_flag_sg13g2_dfrbpq_1_Q_D_sg13g2_inv_1_Y_A_sg13g2_o21ai_1_Y_B1_sg13g2_nand3_1_Y_A_sg13g2_and4_1_A_X_sg13g2_nand3_1_B_C_sg13g2_a22oi_1_Y_B1_sg13g2_xor2_1_X
+ overflow_flag_sg13g2_dfrbpq_1_Q_D_sg13g2_inv_1_Y_A_sg13g2_o21ai_1_Y_B1_sg13g2_nand3_1_Y_A_sg13g2_and4_1_A_X_sg13g2_nand3_1_B_C_sg13g2_a22oi_1_Y/B1
+ VDD overflow_flag_sg13g2_dfrbpq_1_Q_D_sg13g2_inv_1_Y_A_sg13g2_o21ai_1_Y_B1_sg13g2_nand3_1_Y_A_sg13g2_and4_1_A_X_sg13g2_nand3_1_B_C_sg13g2_a22oi_1_Y_B1_sg13g2_xor2_1_X/B
+ overflow_flag_sg13g2_dfrbpq_1_Q_D_sg13g2_inv_1_Y_A_sg13g2_o21ai_1_Y_B1_sg13g2_nand3_1_Y_A_sg13g2_and4_1_A_X_sg13g2_nand3_1_B_C_sg13g2_a22oi_1_Y_B1_sg13g2_xor2_1_X/A
+ VSS sg13g2_xor2_1
Xcarry_flag_sg13g2_o21ai_1_A1_B1_sg13g2_nand2_1_Y_A_sg13g2_nand3_1_Y_A_sg13g2_a21oi_1_B1_Y_sg13g2_a221oi_1_B2_C1_sg13g2_o21ai_1_Y
+ VSS VDD carry_flag_sg13g2_o21ai_1_A1_B1_sg13g2_nand2_1_Y_A_sg13g2_nand3_1_Y_A_sg13g2_a21oi_1_B1_Y_sg13g2_a221oi_1_B2/C1
+ carry_flag_sg13g2_o21ai_1_A1_B1_sg13g2_nand2_1_Y_A_sg13g2_nand3_1_Y_A_sg13g2_a21oi_1_B1_Y_sg13g2_a221oi_1_B2_C1_sg13g2_o21ai_1_Y/B1
+ carry_flag_sg13g2_o21ai_1_A1_B1_sg13g2_nand2_1_Y_A_sg13g2_nand3_1_Y_A_sg13g2_a21oi_1_B1_Y_sg13g2_a221oi_1_B2_C1_sg13g2_o21ai_1_Y/A2
+ carry_flag_sg13g2_o21ai_1_A1_B1_sg13g2_nand2_1_Y_A_sg13g2_nand3_1_Y_A_sg13g2_a21oi_1_B1_Y_sg13g2_a221oi_1_B2_C1_sg13g2_o21ai_1_Y/A1
+ sg13g2_o21ai_1
Xuo_out_sg13g2_dfrbpq_1_Q_6_D_sg13g2_a21oi_1_Y_A2_sg13g2_a21o_1_X_A1_sg13g2_or3_1_X
+ VDD VSS uo_out_sg13g2_dfrbpq_1_Q_6_D_sg13g2_a21oi_1_Y_A2_sg13g2_a21o_1_X_A1_sg13g2_or3_1_X/C
+ uio_in[3] uio_in[4] uo_out_sg13g2_dfrbpq_1_Q_6_D_sg13g2_a21oi_1_Y_A2_sg13g2_a21o_1_X/A1
+ sg13g2_or3_1
Xscan_reg\[10\]_sg13g2_inv_1_A scan_reg\[10\]_sg13g2_inv_1_A/Y scan_reg\[10\]_sg13g2_inv_1_A/A
+ VSS VDD sg13g2_inv_1
Xnegative_flag_sg13g2_dfrbpq_1_Q_D_sg13g2_a21oi_1_Y_A2_sg13g2_o21ai_1_Y_A1_sg13g2_nand2_1_Y
+ negative_flag_sg13g2_dfrbpq_1_Q_D_sg13g2_a21oi_1_Y_A2_sg13g2_o21ai_1_Y/A1 VDD uio_in[0]
+ VSS misr\[1\]_sg13g2_inv_1_A_Y_sg13g2_xnor2_1_A_B_sg13g2_o21ai_1_Y_B1_sg13g2_nand4_1_Y/A
+ sg13g2_nand2_1
Xmisr\[0\]_sg13g2_dfrbpq_1_Q_D_sg13g2_a22oi_1_Y_A1_sg13g2_inv_1_Y misr\[0\]_sg13g2_dfrbpq_1_Q_D_sg13g2_a22oi_1_Y/A1
+ misr\[0\]_sg13g2_dfrbpq_1_Q/Q VSS VDD sg13g2_inv_1
Xmisr\[1\]_sg13g2_inv_1_A_Y_sg13g2_xnor2_1_A_B_sg13g2_o21ai_1_Y_A2_sg13g2_nand3_1_Y_B_sg13g2_nor3_1_Y_B_sg13g2_a21oi_1_B1_A1_sg13g2_o21ai_1_Y_A2_sg13g2_nor2b_1_Y
+ bist_a\[7\]_sg13g2_dfrbpq_1_Q_D_sg13g2_o21ai_1_Y_A1_sg13g2_o21ai_1_A1_B1_sg13g2_nand4_1_C_Y_sg13g2_a221oi_1_C1_B1_sg13g2_nor2_1_Y/A
+ misr\[1\]_sg13g2_inv_1_A_Y_sg13g2_xnor2_1_A_B_sg13g2_o21ai_1_Y_A2_sg13g2_nand3_1_Y_C_sg13g2_a22oi_1_Y_B1_sg13g2_and2_1_X_A_sg13g2_or3_1_X/C
+ VDD misr\[1\]_sg13g2_inv_1_A_Y_sg13g2_xnor2_1_A_B_sg13g2_o21ai_1_Y_A2_sg13g2_nand3_1_Y_B_sg13g2_nor3_1_Y_B_sg13g2_a21oi_1_B1_A1_sg13g2_o21ai_1_Y/A2
+ VSS sg13g2_nor2b_1
Xscan_reg\[29\]_sg13g2_inv_1_A scan_reg\[29\]_sg13g2_inv_1_A/Y scan_reg\[29\]_sg13g2_inv_1_A/A
+ VSS VDD sg13g2_inv_1
Xclkbuf_5_9__f_clk clkload2/A VSS clkbuf_4_4_0_clk/X VDD sg13g2_buf_4
Xbist_a\[7\]_sg13g2_dfrbpq_1_Q_D_sg13g2_o21ai_1_Y_A1_sg13g2_o21ai_1_A1_A2_sg13g2_nand3_1_Y
+ VDD bist_a\[7\]_sg13g2_dfrbpq_1_Q_D_sg13g2_o21ai_1_Y_A1_sg13g2_o21ai_1_A1/A2 bist_a\[7\]_sg13g2_or2_1_A/B
+ bist_a\[7\]_sg13g2_dfrbpq_1_Q_D_sg13g2_o21ai_1_Y_A1_sg13g2_o21ai_1_A1_A2_sg13g2_nand3_1_Y/C
+ bist_a\[2\]_sg13g2_dfrbpq_1_Q_D_sg13g2_o21ai_1_Y/A1 VSS sg13g2_nand3_1
Xoperand_a\[7\]_sg13g2_nand2b_1_A_N VSS operand_a\[7\]_sg13g2_mux2_1_A0/A0 scan_reg\[8\]_sg13g2_o21ai_1_A1/B1
+ ui_in[3] VDD sg13g2_nand2b_1
Xcarry_flag_sg13g2_o21ai_1_A1 VSS VDD carry_flag_sg13g2_o21ai_1_A1/Y carry_flag_sg13g2_o21ai_1_A1/B1
+ ui_in[2] misr\[1\]_sg13g2_a22oi_1_B2/A1 sg13g2_o21ai_1
Xoverflow_flag_sg13g2_dfrbpq_1_Q_D_sg13g2_inv_1_Y_A_sg13g2_o21ai_1_Y_B1_sg13g2_nand3_1_Y_C_sg13g2_a21oi_1_Y_A1_sg13g2_nor3_1_Y
+ serial_b\[6\]_sg13g2_and2_1_A/X overflow_flag_sg13g2_dfrbpq_1_Q_D_sg13g2_inv_1_Y_A_sg13g2_o21ai_1_Y_B1_sg13g2_nand3_1_Y_C_sg13g2_a21oi_1_Y/A1
+ carry_flag_sg13g2_o21ai_1_A1_B1_sg13g2_nand2_1_Y_B_sg13g2_a21oi_1_Y_A2_sg13g2_a21oi_1_Y/A1
+ carry_flag_sg13g2_o21ai_1_A1_B1_sg13g2_nand2_1_Y_B_sg13g2_a21oi_1_Y_A2_sg13g2_a21oi_1_Y_B1_sg13g2_o21ai_1_B1/A2
+ VDD VSS sg13g2_nor3_1
Xbist_pattern_count\[3\]_sg13g2_nand4_1_D_Y_sg13g2_nor2b_1_A bist_pattern_count\[3\]_sg13g2_nand4_1_D/Y
+ bist_pattern_count\[1\]_sg13g2_and3_1_A/C VDD bist_pattern_count\[4\]_sg13g2_and2_1_A/B
+ VSS sg13g2_nor2b_1
Xcarry_flag_sg13g2_o21ai_1_A1_B1_sg13g2_nand2_1_Y_A_sg13g2_nand3_1_Y_A_sg13g2_a21oi_1_B1_Y_sg13g2_a221oi_1_B2_C1_sg13g2_o21ai_1_Y_B1_sg13g2_a221oi_1_Y
+ carry_flag_sg13g2_o21ai_1_A1_B1_sg13g2_nand2_1_Y_A_sg13g2_nand3_1_Y_A_sg13g2_a21oi_1_B1_Y_sg13g2_a221oi_1_B2_C1_sg13g2_o21ai_1_Y_B1_sg13g2_a221oi_1_Y/C1
+ carry_flag_sg13g2_o21ai_1_A1_B1_sg13g2_nand2_1_Y_A_sg13g2_nand3_1_Y_A_sg13g2_a21oi_1_B1_Y_sg13g2_a221oi_1_B2_C1_sg13g2_o21ai_1_Y/B1
+ serial_b\[4\]_sg13g2_nand2_1_A/B serial_opcode\[0\]_sg13g2_o21ai_1_A1/Y overflow_flag_sg13g2_dfrbpq_1_Q_D_sg13g2_inv_1_Y_A_sg13g2_o21ai_1_Y_B1_sg13g2_nand3_1_Y_A_sg13g2_and4_1_A_D_sg13g2_a221oi_1_Y/A2
+ VDD serial_b\[2\]_sg13g2_xor2_1_A/B VSS sg13g2_a221oi_1
Xcycle_counter\[4\]_sg13g2_dfrbpq_1_Q VDD cycle_counter\[4\]_sg13g2_dfrbpq_1_Q/D bist_done_sg13g2_a22oi_1_B2/A1
+ clkbuf_5_15__f_clk/X VSS rst_n sg13g2_dfrbpq_1
Xoverflow_flag_sg13g2_dfrbpq_1_Q_D_sg13g2_inv_1_Y_A_sg13g2_o21ai_1_Y_B1_sg13g2_nand3_1_Y_A_sg13g2_and4_1_A_X_sg13g2_nand3_1_B_C_sg13g2_a22oi_1_Y_A2_sg13g2_nor2_1_Y_B_sg13g2_a21oi_1_Y
+ VDD VSS carry_flag_sg13g2_o21ai_1_A1_B1_sg13g2_nand2_1_Y_A_sg13g2_nand3_1_Y_B_sg13g2_nand3_1_Y/C
+ serial_b\[6\]_sg13g2_nand2b_1_A_N/Y carry_flag_sg13g2_o21ai_1_A1_B1_sg13g2_nand2_1_Y_A_sg13g2_nand3_1_Y_B_sg13g2_nand3_1_C_A_sg13g2_o21ai_1_B1_A2_sg13g2_nor3_1_Y/A
+ uo_out_sg13g2_dfrbpq_1_Q_3_D_sg13g2_o21ai_1_Y_B1_sg13g2_nand2_1_Y_B_sg13g2_a22oi_1_Y_A1_sg13g2_a221oi_1_Y_C1_sg13g2_or4_1_X_C_sg13g2_nor4_1_Y/D
+ sg13g2_a21oi_1
Xscan_reg\[43\]_sg13g2_o21ai_1_A1 VSS VDD scan_reg\[43\]_sg13g2_o21ai_1_A1/Y scan_reg\[43\]_sg13g2_o21ai_1_A1/B1
+ scan_reg\[41\]_sg13g2_nor2_1_A/B scan_reg\[43\]_sg13g2_nor2_1_A/A sg13g2_o21ai_1
Xclkbuf_4_13_0_clk clkbuf_4_13_0_clk/X VSS clkbuf_0_clk/X VDD sg13g2_buf_4
Xscan_out_sg13g2_a22oi_1_A1_A2_sg13g2_nor2_1_Y ui_in[3] VDD scan_out_sg13g2_a22oi_1_A1/A2
+ VSS ui_in[6] sg13g2_nor2_1
Xoperand_a\[2\]_sg13g2_dfrbpq_1_Q VDD operand_a\[2\]_sg13g2_dfrbpq_1_Q/D operand_a\[2\]_sg13g2_inv_1_A/A
+ clkbuf_5_4__f_clk/X VSS rst_n sg13g2_dfrbpq_1
Xscan_reg\[47\]_sg13g2_o21ai_1_A1_B1_sg13g2_nand2b_1_Y VSS fault_counter\[5\]_sg13g2_dfrbpq_1_Q/Q
+ scan_reg\[47\]_sg13g2_o21ai_1_A1/B1 ui_in[3] VDD sg13g2_nand2b_1
Xzero_flag_sg13g2_dfrbpq_1_Q_D_sg13g2_o21ai_1_Y_A2_sg13g2_nand4_1_Y VDD zero_flag_sg13g2_dfrbpq_1_Q_D_sg13g2_o21ai_1_Y/A2
+ uo_out_sg13g2_dfrbpq_1_Q_1_D_sg13g2_a21oi_1_Y/A2 negative_flag_sg13g2_dfrbpq_1_Q_D_sg13g2_a21oi_1_Y/A2
+ VSS uo_out_sg13g2_dfrbpq_1_Q_D_sg13g2_a21oi_1_Y/B1 zero_flag_sg13g2_dfrbpq_1_Q_D_sg13g2_o21ai_1_Y_A2_sg13g2_nand4_1_Y/D
+ sg13g2_nand4_1
Xoperation\[3\]_sg13g2_dfrbpq_1_Q_D_sg13g2_a21oi_1_Y_A1_sg13g2_a21oi_1_A1 VDD VSS
+ serial_opcode\[1\]_sg13g2_nor2_1_A/Y operation\[3\]_sg13g2_dfrbpq_1_Q_D_sg13g2_a21oi_1_Y/A1
+ carry_flag_sg13g2_o21ai_1_A1_B1_sg13g2_nand2_1_Y_A_sg13g2_nand3_1_Y/C operation\[3\]_sg13g2_dfrbpq_1_Q_D_sg13g2_a21oi_1_Y_A1_sg13g2_a21oi_1_A1/Y
+ sg13g2_a21oi_1
Xbist_a\[7\]_sg13g2_dfrbpq_1_Q_D_sg13g2_o21ai_1_Y_A1_sg13g2_nand2_1_A_B_sg13g2_o21ai_1_A2_B1_sg13g2_a21oi_1_Y_A2_sg13g2_a21o_1_X_A2_sg13g2_nor2_1_Y
+ bist_a\[2\]_sg13g2_dfrbpq_1_Q/Q VDD bist_a\[7\]_sg13g2_dfrbpq_1_Q_D_sg13g2_o21ai_1_Y_A1_sg13g2_nand2_1_A_Y_sg13g2_a221oi_1_A1_A2_sg13g2_nand3_1_Y_C_sg13g2_nand3_1_Y/C
+ VSS bist_a\[7\]_sg13g2_or2_1_A/B sg13g2_nor2_1
Xlfsr\[7\]_sg13g2_xnor2_1_B_Y_sg13g2_xnor2_1_A lfsr\[7\]_sg13g2_xnor2_1_B_Y_sg13g2_xnor2_1_A/Y
+ lfsr\[7\]_sg13g2_xnor2_1_B_Y_sg13g2_xnor2_1_A/B VDD lfsr\[7\]_sg13g2_xnor2_1_B/Y
+ VSS sg13g2_xnor2_1
Xuo_out_sg13g2_dfrbpq_1_Q_6_D_sg13g2_a21oi_1_Y_A2_sg13g2_a21o_1_X_A2_sg13g2_and2_1_X_A_sg13g2_a221oi_1_Y_B2_sg13g2_and2_1_X_B_sg13g2_o21ai_1_Y_A2_sg13g2_a221oi_1_Y
+ uo_out_sg13g2_dfrbpq_1_Q_D_sg13g2_a21oi_1_Y_B1_sg13g2_a21oi_1_Y_A1_sg13g2_nand3_1_Y_B_sg13g2_a221oi_1_Y_B1_sg13g2_xnor2_1_Y_A_sg13g2_a21oi_1_Y/B1
+ uo_out_sg13g2_dfrbpq_1_Q_6_D_sg13g2_a21oi_1_Y_A2_sg13g2_a21o_1_X_A2_sg13g2_and2_1_X_A_sg13g2_a221oi_1_Y_B2_sg13g2_and2_1_X_B_sg13g2_o21ai_1_Y/A2
+ uo_out_sg13g2_dfrbpq_1_Q_D_sg13g2_a21oi_1_Y_B1_sg13g2_a21oi_1_Y_A1_sg13g2_nand3_1_Y_B_sg13g2_a221oi_1_Y_B1_sg13g2_xnor2_1_Y_A_sg13g2_a21oi_1_Y/A2
+ uo_out_sg13g2_dfrbpq_1_Q_D_sg13g2_a21oi_1_Y_B1_sg13g2_a21oi_1_Y_A1_sg13g2_nand3_1_Y_B_sg13g2_a221oi_1_Y_B1_sg13g2_xnor2_1_Y_A_sg13g2_a21oi_1_Y/A1
+ serial_b\[3\]_sg13g2_inv_1_A/Y VDD serial_a\[3\]_sg13g2_dfrbpq_1_Q/Q VSS sg13g2_a221oi_1
Xbist_a\[7\]_sg13g2_dfrbpq_1_Q_D_sg13g2_o21ai_1_Y_A1_sg13g2_nand2_1_A_Y_sg13g2_a221oi_1_B2_Y_sg13g2_o21ai_1_B1_A1_sg13g2_nor3_1_Y_C_sg13g2_a221oi_1_Y
+ misr\[1\]_sg13g2_inv_1_A_Y_sg13g2_xnor2_1_A_B_sg13g2_o21ai_1_Y_A2_sg13g2_nand3_1_Y_C_sg13g2_a22oi_1_Y_A2_sg13g2_xnor2_1_Y_B_sg13g2_a21oi_1_Y/B1
+ bist_a\[7\]_sg13g2_dfrbpq_1_Q_D_sg13g2_o21ai_1_Y_A1_sg13g2_nand2_1_A_Y_sg13g2_a221oi_1_B2_Y_sg13g2_o21ai_1_B1_A1_sg13g2_nor3_1_Y/C
+ misr\[1\]_sg13g2_inv_1_A_Y_sg13g2_xnor2_1_A_B_sg13g2_o21ai_1_Y_A2_sg13g2_nand3_1_Y_C_sg13g2_a22oi_1_Y_A2_sg13g2_xnor2_1_Y_B_sg13g2_a21oi_1_Y/A2
+ misr\[1\]_sg13g2_inv_1_A_Y_sg13g2_xnor2_1_A_B_sg13g2_o21ai_1_Y_A2_sg13g2_nand3_1_Y_C_sg13g2_a22oi_1_Y_A2_sg13g2_xnor2_1_Y_B_sg13g2_a21oi_1_Y/A1
+ misr\[1\]_sg13g2_inv_1_A_Y_sg13g2_xnor2_1_A_B_sg13g2_o21ai_1_Y_A2_sg13g2_nand3_1_Y_C_sg13g2_a22oi_1_Y_A2_sg13g2_xnor2_1_Y_A_sg13g2_and2_1_X/B
+ VDD bist_a\[7\]_sg13g2_dfrbpq_1_Q_D_sg13g2_o21ai_1_Y_A1_sg13g2_nand2_1_A_Y_sg13g2_a221oi_1_B2_A2_sg13g2_xnor2_1_Y_B_sg13g2_and2_1_X/A
+ VSS sg13g2_a221oi_1
Xmisr\[7\]_sg13g2_dfrbpq_1_Q_D_sg13g2_a22oi_1_Y_B2_sg13g2_o21ai_1_Y_A2_sg13g2_a22oi_1_Y_B1_sg13g2_mux2_1_X
+ misr\[4\]_sg13g2_inv_1_A_Y_sg13g2_xnor2_1_A_B_sg13g2_o21ai_1_Y_A2_sg13g2_o21ai_1_Y/A1
+ misr\[7\]_sg13g2_dfrbpq_1_Q_D_sg13g2_a22oi_1_Y_B2_sg13g2_o21ai_1_Y_A2_sg13g2_a22oi_1_Y/B1
+ misr\[7\]_sg13g2_dfrbpq_1_Q_D_sg13g2_a22oi_1_Y_B2_sg13g2_o21ai_1_Y_A2_sg13g2_a22oi_1_Y/A1
+ VDD VSS misr\[7\]_sg13g2_dfrbpq_1_Q_D_sg13g2_a22oi_1_Y_B2_sg13g2_o21ai_1_Y_A2_sg13g2_a22oi_1_Y_B1_sg13g2_mux2_1_X/A0
+ sg13g2_mux2_1
Xoverflow_flag_sg13g2_dfrbpq_1_Q_D_sg13g2_inv_1_Y_A_sg13g2_o21ai_1_Y_B1_sg13g2_nand3_1_Y_A_sg13g2_and4_1_A_D_sg13g2_a221oi_1_Y_C1_sg13g2_nor2_1_Y_B_sg13g2_a22oi_1_Y
+ overflow_flag_sg13g2_dfrbpq_1_Q_D_sg13g2_inv_1_Y_A_sg13g2_o21ai_1_Y_B1_sg13g2_nand3_1_Y_A_sg13g2_and4_1_A_D_sg13g2_a221oi_1_Y_C1_sg13g2_nor2_1_Y/B
+ serial_opcode\[1\]_sg13g2_nor2_1_A/Y VDD serial_opcode\[1\]_sg13g2_nor2b_1_B_N/Y
+ serial_a\[7\]_sg13g2_dfrbpq_1_Q/Q VSS serial_b\[0\]_sg13g2_xnor2_1_B/A sg13g2_a22oi_1
Xuo_out_sg13g2_dfrbpq_1_Q_5_D_sg13g2_a21oi_1_Y_B1_sg13g2_nor2_1_Y uo_out[5] VDD uo_out_sg13g2_dfrbpq_1_Q_5_D_sg13g2_a21oi_1_Y/B1
+ VSS ui_in[2] sg13g2_nor2_1
Xbist_fault_sg13g2_nor2b_1_A bist_fault_sg13g2_nor2_1_B/B lfsr\[7\]_sg13g2_a22oi_1_A1/A2
+ VDD bist_fault_sg13g2_nor2b_1_A/Y VSS sg13g2_nor2b_1
Xfault_counter\[2\]_sg13g2_dfrbpq_1_Q_D_sg13g2_xnor2_1_Y fault_counter\[2\]_sg13g2_dfrbpq_1_Q/D
+ fault_counter\[2\]_sg13g2_dfrbpq_1_Q_D_sg13g2_xnor2_1_Y/B VDD scan_reg\[44\]_sg13g2_dfrbpq_1_Q_D_sg13g2_a221oi_1_Y/A2
+ VSS sg13g2_xnor2_1
Xcarry_flag_sg13g2_o21ai_1_A1_B1_sg13g2_nand2_1_Y_A_sg13g2_nand3_1_Y_B_sg13g2_nand3_1_Y_A_sg13g2_nor3_1_A
+ carry_flag_sg13g2_o21ai_1_A1_B1_sg13g2_nand2_1_Y_A_sg13g2_nand3_1_Y_B_sg13g2_nand3_1_Y/A
+ carry_flag_sg13g2_o21ai_1_A1_B1_sg13g2_nand2_1_Y_A_sg13g2_nand3_1_Y_B_sg13g2_nand3_1_Y_A_sg13g2_nor3_1_A/Y
+ carry_flag_sg13g2_o21ai_1_A1_B1_sg13g2_nand2_1_Y_A_sg13g2_nand3_1_Y_B_sg13g2_nand3_1_Y_A_sg13g2_nor3_1_A/B
+ carry_flag_sg13g2_o21ai_1_A1_B1_sg13g2_nand2_1_Y_A_sg13g2_nand3_1_Y_B_sg13g2_nand3_1_Y_A_sg13g2_nor3_1_A/C
+ VDD VSS sg13g2_nor3_1
Xbist_pattern_count\[6\]_sg13g2_nand3_1_C_Y_sg13g2_nor2_1_B_Y_sg13g2_nand2_1_B bist_state\[2\]_sg13g2_dfrbpq_1_Q_D_sg13g2_a21o_1_X/A2
+ VDD bist_pattern_count\[7\]_sg13g2_dfrbpq_1_Q/Q VSS bist_pattern_count\[6\]_sg13g2_nand3_1_C_Y_sg13g2_nor2_1_B/Y
+ sg13g2_nand2_1
Xmisr\[1\]_sg13g2_dfrbpq_1_Q_D_sg13g2_a22oi_1_Y_B2_sg13g2_o21ai_1_Y_A2_sg13g2_a22oi_1_Y_A2_sg13g2_and2_1_X_A_sg13g2_a21oi_1_Y
+ VDD VSS bist_a\[7\]_sg13g2_dfrbpq_1_Q_D_sg13g2_o21ai_1_Y_A1_sg13g2_o21ai_1_A1_Y_sg13g2_nand2b_1_A_N_B_sg13g2_a21oi_1_Y/A2
+ misr\[1\]_sg13g2_dfrbpq_1_Q_D_sg13g2_a22oi_1_Y_B2_sg13g2_o21ai_1_Y_A2_sg13g2_a22oi_1_Y_A2_sg13g2_and2_1_X_A_sg13g2_a21oi_1_Y/A1
+ bist_a\[7\]_sg13g2_dfrbpq_1_Q_D_sg13g2_o21ai_1_Y_A1_sg13g2_nand2_1_A_B_sg13g2_o21ai_1_A2_B1_sg13g2_nand3_1_C/Y
+ misr\[1\]_sg13g2_dfrbpq_1_Q_D_sg13g2_a22oi_1_Y_B2_sg13g2_o21ai_1_Y_A2_sg13g2_a22oi_1_Y_A2_sg13g2_and2_1_X/A
+ sg13g2_a21oi_1
Xfault_counter\[1\]_sg13g2_dfrbpq_1_Q VDD fault_counter\[1\]_sg13g2_dfrbpq_1_Q/D fault_counter\[1\]_sg13g2_dfrbpq_1_Q/Q
+ clkload2/A VSS rst_n sg13g2_dfrbpq_1
Xoperation\[3\]_sg13g2_dfrbpq_1_Q_D_sg13g2_a21oi_1_Y_A1_sg13g2_a21oi_1_A1_Y_sg13g2_nor2_1_B_Y_sg13g2_a21oi_1_B1_Y_sg13g2_nand3_1_A_B_sg13g2_nand2b_1_Y_A_N_sg13g2_xnor2_1_B
+ overflow_flag_sg13g2_dfrbpq_1_Q_D_sg13g2_inv_1_Y_A_sg13g2_o21ai_1_Y_B1_sg13g2_nand3_1_Y_A_sg13g2_nand2_1_Y_B_sg13g2_a21oi_1_Y_A2_sg13g2_nand3_1_C_Y_sg13g2_nand3_1_B/C
+ operation\[3\]_sg13g2_dfrbpq_1_Q_D_sg13g2_a21oi_1_Y_A1_sg13g2_a21oi_1_A1_Y_sg13g2_nor2_1_B_Y_sg13g2_a21oi_1_B1_Y_sg13g2_nand3_1_A_B_sg13g2_nand2b_1_Y/A_N
+ VDD serial_b\[1\]_sg13g2_xor2_1_A/X VSS sg13g2_xnor2_1
Xoperand_b\[2\]_sg13g2_dfrbpq_1_Q_D_sg13g2_a21oi_1_Y VDD VSS ui_in[2] serial_b\[2\]_sg13g2_dfrbpq_1_Q_D_sg13g2_o21ai_1_Y/A1
+ operand_b\[2\]_sg13g2_nor2_1_A/Y operand_b\[2\]_sg13g2_dfrbpq_1_Q/D sg13g2_a21oi_1
Xoverflow_flag_sg13g2_dfrbpq_1_Q_D_sg13g2_inv_1_Y_A_sg13g2_o21ai_1_Y_B1_sg13g2_nand3_1_Y_A_sg13g2_and4_1_A_X_sg13g2_nand3_1_B_C_sg13g2_a22oi_1_Y_A2_sg13g2_nor2_1_Y
+ carry_flag_sg13g2_o21ai_1_A1_B1_sg13g2_nand2_1_Y_A_sg13g2_nand3_1_Y_B_sg13g2_nand3_1_C_A_sg13g2_o21ai_1_B1/A1
+ VDD overflow_flag_sg13g2_dfrbpq_1_Q_D_sg13g2_inv_1_Y_A_sg13g2_o21ai_1_Y_B1_sg13g2_nand3_1_Y_A_sg13g2_and4_1_A_X_sg13g2_nand3_1_B_C_sg13g2_a22oi_1_Y/A2
+ VSS uo_out_sg13g2_dfrbpq_1_Q_3_D_sg13g2_o21ai_1_Y_B1_sg13g2_nand2_1_Y_B_sg13g2_a22oi_1_Y_A1_sg13g2_a221oi_1_Y_C1_sg13g2_or4_1_X_C_sg13g2_nor4_1_Y/D
+ sg13g2_nor2_1
Xserial_a\[1\]_sg13g2_dfrbpq_1_Q VDD serial_a\[1\]_sg13g2_dfrbpq_1_Q/D serial_b\[1\]_sg13g2_xor2_1_A/B
+ clkload1/A VSS rst_n sg13g2_dfrbpq_1
Xlfsr\[7\]_sg13g2_dfrbpq_1_Q_D_sg13g2_inv_1_Y lfsr\[7\]_sg13g2_dfrbpq_1_Q/D lfsr\[7\]_sg13g2_a22oi_1_A1/Y
+ VSS VDD sg13g2_inv_1
Xoperand_b\[5\]_sg13g2_dfrbpq_1_Q VDD operand_b\[5\]_sg13g2_mux2_1_A0/X operand_b\[5\]_sg13g2_inv_1_A/A
+ clkbuf_5_21__f_clk/X VSS rst_n sg13g2_dfrbpq_1
Xserial_opcode\[0\]_sg13g2_o21ai_1_A1 VSS VDD serial_opcode\[0\]_sg13g2_o21ai_1_A1/Y
+ serial_opcode\[0\]_sg13g2_o21ai_1_A1/B1 serial_opcode\[3\]_sg13g2_nand2_1_B/Y operation\[0\]_sg13g2_mux2_1_A0/A1
+ sg13g2_o21ai_1
Xmisr\[1\]_sg13g2_inv_1_A_Y_sg13g2_xnor2_1_A_B_sg13g2_o21ai_1_Y_A2_sg13g2_nand3_1_Y_C_sg13g2_a22oi_1_Y_A2_sg13g2_xnor2_1_Y_A_sg13g2_o21ai_1_A1_B1_sg13g2_nand2_1_Y
+ misr\[1\]_sg13g2_inv_1_A_Y_sg13g2_xnor2_1_A_B_sg13g2_o21ai_1_Y_A2_sg13g2_nand3_1_Y_C_sg13g2_a22oi_1_Y_A2_sg13g2_xnor2_1_Y_A_sg13g2_o21ai_1_A1/B1
+ VDD bist_a\[2\]_sg13g2_dfrbpq_1_Q_D_sg13g2_o21ai_1_Y/A1 VSS lfsr\[6\]_sg13g2_mux2_1_A1/A0
+ sg13g2_nand2_1
Xfault_counter\[5\]_sg13g2_dfrbpq_1_Q_D_sg13g2_and2_1_X_B_sg13g2_a21o_1_X fault_counter\[5\]_sg13g2_dfrbpq_1_Q/Q
+ fault_counter\[5\]_sg13g2_dfrbpq_1_Q_D_sg13g2_and2_1_X/B VDD VSS misr\[4\]_sg13g2_a22oi_1_B2/A1
+ fault_counter\[3\]_sg13g2_dfrbpq_1_Q_D_sg13g2_nor2_1_Y/A sg13g2_a21o_1
Xbist_a\[0\]_sg13g2_dfrbpq_1_Q VDD bist_a\[0\]_sg13g2_dfrbpq_1_Q/D bist_a\[0\]_sg13g2_dfrbpq_1_Q/Q
+ clkbuf_5_3__f_clk/X VSS rst_n sg13g2_dfrbpq_1
.ends
